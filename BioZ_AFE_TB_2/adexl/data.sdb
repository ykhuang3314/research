ADE simulation setup
Run mode: Single Run, Sweeps and Corners
Tests:
  BioZ_EMG_Model:BioZ_AFE_TB_2:ALL: BioZ_EMG_Model/BioZ_AFE_TB_2/config, simulator ams
    Outputs: Zin_mag; real_spectrum; imag_spectrum; mag_spectrum; pha_spectrum; input_referred_noise_current; IoutDC; GainDC; G0; EP; EN; IM2; IM3; IM2_val; IM3_val; IM2_dB; IM3_dB; Zin_pha; Resolution_rms; integrated_noise; input_referred_noise_voltage; "/Isource/MINUS"; Isource_rms; Resolution; MIX_diff_I; MIX_diff_Q; TIA_diff_I; TIA_diff1_Q; LPF_diff_I; LPF_diff_Q; TCA_diff_I; TCA_diff_Q; mag_rmsd; pha_rmsd; (IT); mag_d; pha_d; Isource_trans
Global variables:
  freq_bioz = {From/To}Logarithmic:976.563:11:1M{From/To}
  a1 = 0.95
  a2 = 0.88
  a3 = 0.86
  R1 = 10.5
  R2 = 8.7
  R3 = 1.8
  Rinf = 6
  Z1 = 2.4k
  Z2 = 1.7M
  Z3 = 6k
  IS = -100u
  IS_DC = 0
  IS_offset = 0
  IS_phase_AC = 90
  IS_phase_trans = 90
  IS_pk = 100u
  t_meas = 4.5m
