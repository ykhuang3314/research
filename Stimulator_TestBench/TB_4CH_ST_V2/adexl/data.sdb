ADE simulation setup
Run mode: Single Run, Sweeps and Corners
Tests:
  Stimulator_TestBench:TB_4CH_ST_V2:1: Stimulator_TestBench/TB_4CH_ST_V2/config, simulator ams
