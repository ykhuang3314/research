ADE simulation setup
Run mode: Single Run, Sweeps and Corners
Tests:
  Stimulator_TestBench:TB_Iref_imp:1: Stimulator_TestBench/TB_Iref_imp/schematic, simulator spectre
Global variables:
  vdd = 3.3
Corners (nominal off):
  model folders: /pkg/xfab/XKIT/xh018/cadence/v8_0/spectre/v8_0_1/lpmos
  C0: vdd=3.3; param.scs[3s], bip.scs[tm], cap.scs[tm wp ws], dio.scs[tm], mos.scs[wo wp ws wz], photo.scs[tm], res.scs[wp ws]
