ADE simulation setup
Run mode: Single Run, Sweeps and Corners
Tests:
  Stimulator_TestBench:TB_4CH_ST_Behav:1: Stimulator_TestBench/TB_4CH_ST_Behav/config, simulator ams
