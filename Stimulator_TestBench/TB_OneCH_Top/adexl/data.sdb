ADE simulation setup
Run mode: Single Run, Sweeps and Corners
Tests:
  Stimulator_TestBench:TB_OneCH_Top:1: Stimulator_TestBench/TB_OneCH_Top/config, simulator ams
Global variables:
  Rload = {From/To}Auto:100:5:1200{From/To}
Corners:
  model folders: /pkg/xfab/XKIT/xh018/cadence/v8_0/spectre/v8_0_1/lpmos
  C0: param.scs[3s], bip.scs[tm], cap.scs[wp ws], dio.scs[tm], mos.scs[wo wp ws wz], photo.scs[tm], res.scs[wp ws]
