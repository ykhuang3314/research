ADE simulation setup
Run mode: Single Run, Sweeps and Corners
Tests:
  Stimulator_TestBench:TB_OneChannel_DC_imp:1: Stimulator_TestBench/TB_OneChannel_DC_imp/schematic, simulator spectre
Global variables:
  Rload = {From/To}Linear:100:200:1300{From/To}
