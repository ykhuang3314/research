// Momentum eesofbbs_64 12.00 (*) built: Jan 14 2016
//**************************************************

simulator lang=spectre

//bbspice subcircuit with consecutive port numbers.
subckt bbspice_Sparam_BioZ_arm_2cm_subckt (port_1	port_2	port_3	gnd_0)

//PORT_1
vi_1	(port_1	_net_1)	vsource type=dc dc=0.00000000000000e+00
vb_1	(_net_4	_net_5)	vsource type=dc dc=0.00000000000000e+00
R_Z0_1	(_net_1	_net_2)	res r=5.00000000000000e+01	isnoisy=no
H_b_1	(_net_2	gnd_0)	ccvs probe=vb_1 rm=1.41421356237310e+01
E_v_1	(_net_3	gnd_0	port_1	gnd_0)	vcvs gain=7.07106781186548e-02
H_i_1	(_net_4	_net_3)	ccvs probe=vi_1 rm=3.53553390593274e+00

G_port1_port1_p1 (_net_5	gnd_0	_net_5	gnd_0) svccs gainfactor=3.16934703679716e+03 poles=[-8.05020102709532e+04	0.0]//Real pole
G_port1_port1_p2 (_net_5	gnd_0	_net_5	gnd_0) svccs gainfactor=1.89852688956469e+10 poles=[-1.97703193314267e+10	0.0]//Real pole
G_port1_port2_p1 (_net_5	gnd_0	_net_10	gnd_0) svccs gainfactor=-1.06862426742803e+03 poles=[-8.05020102709532e+04	0.0]//Real pole
G_port1_port2_p2 (_net_5	gnd_0	_net_10	gnd_0) svccs gainfactor=2.64020205900108e+08 poles=[-1.97703193314267e+10	0.0]//Real pole
G_port1_port3_p1 (_net_5	gnd_0	_net_15	gnd_0) svccs gainfactor=-1.04302053052246e+03 poles=[-8.05020102709532e+04	0.0]//Real pole
G_port1_port3_p2 (_net_5	gnd_0	_net_15	gnd_0) svccs gainfactor=2.58200400504944e+08 poles=[-1.97703193314267e+10	0.0]//Real pole

//PORT_2
vi_2	(port_2	_net_6)	vsource type=dc dc=0.00000000000000e+00
vb_2	(_net_9	_net_10)	vsource type=dc dc=0.00000000000000e+00
R_Z0_2	(_net_6	_net_7)	res r=5.00000000000000e+01	isnoisy=no
H_b_2	(_net_7	gnd_0)	ccvs probe=vb_2 rm=1.41421356237310e+01
E_v_2	(_net_8	gnd_0	port_2	gnd_0)	vcvs gain=7.07106781186548e-02
H_i_2	(_net_9	_net_8)	ccvs probe=vi_2 rm=3.53553390593274e+00

G_port2_port1_p1 (_net_10	gnd_0	_net_5	gnd_0) svccs gainfactor=-1.06862426742803e+03 poles=[-8.05020102709532e+04	0.0]//Real pole
G_port2_port1_p2 (_net_10	gnd_0	_net_5	gnd_0) svccs gainfactor=2.64020205900108e+08 poles=[-1.97703193314267e+10	0.0]//Real pole
G_port2_port2_p1 (_net_10	gnd_0	_net_10	gnd_0) svccs gainfactor=3.19093039613343e+03 poles=[-8.05020102709532e+04	0.0]//Real pole
G_port2_port2_p2 (_net_10	gnd_0	_net_10	gnd_0) svccs gainfactor=1.89803400637876e+10 poles=[-1.97703193314267e+10	0.0]//Real pole
G_port2_port3_p1 (_net_10	gnd_0	_net_15	gnd_0) svccs gainfactor=-1.05776723435560e+03 poles=[-8.05020102709532e+04	0.0]//Real pole
G_port2_port3_p2 (_net_10	gnd_0	_net_15	gnd_0) svccs gainfactor=2.61536998092345e+08 poles=[-1.97703193314267e+10	0.0]//Real pole

//PORT_3
vi_3	(port_3	_net_11)	vsource type=dc dc=0.00000000000000e+00
vb_3	(_net_14	_net_15)	vsource type=dc dc=0.00000000000000e+00
R_Z0_3	(_net_11	_net_12)	res r=5.00000000000000e+01	isnoisy=no
H_b_3	(_net_12	gnd_0)	ccvs probe=vb_3 rm=1.41421356237310e+01
E_v_3	(_net_13	gnd_0	port_3	gnd_0)	vcvs gain=7.07106781186548e-02
H_i_3	(_net_14	_net_13)	ccvs probe=vi_3 rm=3.53553390593274e+00

G_port3_port1_p1 (_net_15	gnd_0	_net_5	gnd_0) svccs gainfactor=-1.04302053052246e+03 poles=[-8.05020102709532e+04	0.0]//Real pole
G_port3_port1_p2 (_net_15	gnd_0	_net_5	gnd_0) svccs gainfactor=2.58200400504944e+08 poles=[-1.97703193314267e+10	0.0]//Real pole
G_port3_port2_p1 (_net_15	gnd_0	_net_10	gnd_0) svccs gainfactor=-1.05776723435560e+03 poles=[-8.05020102709532e+04	0.0]//Real pole
G_port3_port2_p2 (_net_15	gnd_0	_net_10	gnd_0) svccs gainfactor=2.61536998092345e+08 poles=[-1.97703193314267e+10	0.0]//Real pole
G_port3_port3_p1 (_net_15	gnd_0	_net_15	gnd_0) svccs gainfactor=3.19138408368800e+03 poles=[-8.05020102709532e+04	0.0]//Real pole
G_port3_port3_p2 (_net_15	gnd_0	_net_15	gnd_0) svccs gainfactor=1.89802378394015e+10 poles=[-1.97703193314267e+10	0.0]//Real pole

ends bbspice_Sparam_BioZ_arm_2cm_subckt
//**************************************************

//S-based subckt
//bbspice subcircuit with external port numbers.

subckt bbspice_Sparam_BioZ_arm_2cm	(1	2	3	ref)
x_	(1	2	3	ref)	bbspice_Sparam_BioZ_arm_2cm_subckt
ends bbspice_Sparam_BioZ_arm_2cm

//**************************************************
