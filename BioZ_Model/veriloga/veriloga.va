// VerilogA for BioZ_EMG_Model, BioZ_Model, veriloga

`include "constants.vams"
`include "disciplines.vams"

module BioZ_Model(t1,t2);

inout t1,t2;
electrical t1,t2,n1,n2;

parameter real tf = 4m;
parameter real tf0 = 4m;
parameter real tm = 8m;
parameter real tm0 = 8m;
parameter real IED = 40m;
parameter real limb = 1; // 1 = Upper Arm ; 2 = Lower Leg

real Rinf;
real R1,R2,R3;
real C1,C2,C3;
real alpha1,alpha2,alpha3;

real R10,R20,R30,R11,R21,R31,R12,R22,R32,R13,R23,R33,R14,R24,R34;
real C10,C20,C30,C11,C21,C31,C12,C22,C32,C13,C23,C33,C14,C24,C34;

analog begin
	@(initial_step) begin
//------------------------------ARM-------------------------------//
	if (limb == 1) begin
		if(IED == 40m) begin
			Rinf = 5;
			R10 = 53.6034;
			R20 = 24.6863;
			R30 = 58.4264;
			C10 = 6.9873e-5;
			C20 = 1.6097e-4;
			C30 = 2.6242e-7;
			alpha1 = 0.9899;
			alpha2 = 0.6430;
			alpha3 = 0.8351;
			R11 = -547.886691701476; C11 = 0.000814928145723549;
			R12 = 184649.049909962;  C12 = 0.505418088077922;
			R13 = -7133.62896778882; C13 = 0.0115229514717979;
			R14 = 404925.074612789;  C14 = 0.0684198688471808;
			R21 = -852.939431598164; C21 = -0.0136760312619277;
			R22 = 490830.617478031;  C22 = 0.500281542089184;
			R23 = -4031.86874892702; C23 = 0.0316427086016746;
			R24 = 248688.513169548;  C24 = 1.05883209263793;
			R31 = 128.171495139826;  C31 = 1.57980514770439e-05;
			R32 = 54173.8600184787;  C32 = -6.83584720004613e-06;
			R33 = -7276.19978896255; C33 = 2.15590188997655e-05;
			R34 = 402317.165441729;  C34 = -0.000762612841655925;

		end else if (IED == 25m) begin
			Rinf = 4;
			R10 = 43.9237;
			R20 = 27.5111;
			R30 = 49.1546;
			C10 = 1.1580e-4;
			C20 = 7.0e-5;
			C30 = 3.4066e-7;
			alpha1 = 0.98;
			alpha2 = 0.65;
			alpha3 = 0.84;
			R11 = 3037.86655016703;  C11 = 0.0186163348359895;
			R12 = 1371825.24070149;  C12 = -2.63708391773009;
			R13 = -4398.98785947656; C13 = 0.0210457472571047;
			R14 = 235316.233845250;  C14 = -0.167744196867776;
			R21 = 9612.81420951600;  C21 = -0.00693100776640960;
			R22 = 584181.571679630;  C22 = 0.293110929436639;
			R23 = -2821.09483279558; C23 = 0.00727463087107129;
			R24 = 162203.084286783;  C24 = -0.535274849050139;
			R31 = 3418.82374285121;  C31 = 2.97604007380933e-05;
			R32 = -170239.114655390; C32 = -0.000571683940811598;
			R33 = -4919.56065972178; C33 = 2.14699042284518e-05;
			R34 = 273408.257372143;  C34 = 0.000155752744839173;

		end else begin //40 mm IED by default
			Rinf = 5;
			R10 = 53.6034;
			R20 = 24.6863;
			R30 = 58.4264;
			C10 = 6.9873e-5;
			C20 = 1.6097e-4;
			C30 = 2.6242e-7;
			alpha1 = 0.9899;
			alpha2 = 0.6430;
			alpha3 = 0.8351;
			R11 = -547.886691701476; C11 = 0.000814928145723549;
			R12 = 184649.049909962;  C12 = 0.505418088077922;
			R13 = -7133.62896778882; C13 = 0.0115229514717979;
			R14 = 404925.074612789;  C14 = 0.0684198688471808;
			R21 = -852.939431598164; C21 = -0.0136760312619277;
			R22 = 490830.617478031;  C22 = 0.500281542089184;
			R23 = -4031.86874892702; C23 = 0.0316427086016746;
			R24 = 248688.513169548;  C24 = 1.05883209263793;
			R31 = 128.171495139826;  C31 = 1.57980514770439e-05;
			R32 = 54173.8600184787;  C32 = -6.83584720004613e-06;
			R33 = -7276.19978896255; C33 = 2.15590188997655e-05;
			R34 = 402317.165441729;  C34 = -0.000762612841655925;

		end
//------------------------------LEG-------------------------------//
	end else if (limb == 2) begin
		if(IED == 40m) begin
			Rinf = 4.00000000131724;
			R10 = 10.1674554177724;
			R20 = 2.94554656910214;
			R30 = 12.0306452749745;
			C10 = 0.000348996358676038;
			C20 = 0.000999999999158306;
			C30 = 6.95100805972859e-07;
			alpha1 = 0.989999999993524;
			alpha2 = 0.649999999997030;
			alpha3 = 0.839999999999849;
			R11 = -986.748050966355; C11 = 0.0391382972203681;
			R12 = 279838.659612327; C12 = -1.77458558049850;
			R13 = -81.9414576904767; C13 = 0.00242396988706886;
			R14 = 2171.55735255924; C14 = 0.0130787739645647;
			R21 = -781.470662565004; C21 = -0.161893141163748;
			R22 = 282910.393566181; C22 = 6.38246824914919;
			R23 = -33.5398852562439; C23 = -5.75361296010901e-09;
			R24 = 1140.51412088682; C24 = 2.52724589386802e-07;
			R31 = 790.866633031291; C31 = 3.49268898333631e-05;
			R32 = 34575.9136671119; C32 = -0.000961501897086013;
			R33 = -120.674353188339; C33 = 7.24240716342318e-06;
			R34 = 3179.80823298179; C34 = -0.000109270646612609;

		end else if (IED == 25m) begin
			Rinf = 4.20738378949421;
			R10 = 14.9203349791681;
			R20 = 7.32993644807337;
			R30 = 18.6367005202724;
			C10 = 0.000149801202113412;
			C20 = 5.09983057312757e-05;
			C30 = 1.09295424053004e-06;
			alpha1 = 0.989999999999971;
			alpha2 = 0.646162229534377;
			alpha3 = 0.830010386212741;
			R11 = 162.714659456627; C11 = -0.000556499839822673;
			R12 = 1461624.86738271; C12 = 0.0326255230147057;
			R13 = 12.7060845305077; C13 = 0.000447641151381758;
			R14 = -3949.83576907587; C14 = 0.323522780500427;
			R21 = -2147.48760526430; C21 = 0.00968617595555449;
			R22 = 1580103.14698757; C22 = -1.38577191808764;
			R23 = 67.5881436451375; C23 = -0.00120698663738629;
			R24 = -3930.26304583661; C24 = 0.0549119257240738;
			R31 = 5841.54034436395; C31 = 2.87761089194639e-05;
			R32 = -395233.546351886; C32 = -0.00636007877379968;
			R33 = -98.9512977954079; C33 = 4.54671288312087e-06;
			R34 = 1242.45252647223; C34 = -0.000939104032428030;

		end else begin //40 mm IED by default
			Rinf = 4.00000000131724;
			R10 = 10.1674554177724;
			R20 = 2.94554656910214;
			R30 = 12.0306452749745;
			C10 = 0.000348996358676038;
			C20 = 0.000999999999158306;
			C30 = 6.95100805972859e-07;
			alpha1 = 0.989999999993524;
			alpha2 = 0.649999999997030;
			alpha3 = 0.839999999999849;
			R11 = -986.748050966355; C11 = 0.0391382972203681;
			R12 = 279838.659612327; C12 = -1.77458558049850;
			R13 = -81.9414576904767; C13 = 0.00242396988706886;
			R14 = 2171.55735255924; C14 = 0.0130787739645647;
			R21 = -781.470662565004; C21 = -0.161893141163748;
			R22 = 282910.393566181; C22 = 6.38246824914919;
			R23 = -33.5398852562439; C23 = -5.75361296010901e-09;
			R24 = 1140.51412088682; C24 = 2.52724589386802e-07;
			R31 = 790.866633031291; C31 = 3.49268898333631e-05;
			R32 = 34575.9136671119; C32 = -0.000961501897086013;
			R33 = -120.674353188339; C33 = 7.24240716342318e-06;
			R34 = 3179.80823298179; C34 = -0.000109270646612609;

		end
//------------------------------DEFAULT-------------------------------//
	end else begin //Upper arm by default
		if(IED == 40m) begin
			Rinf = 5;
			R10 = 53.6034;
			R20 = 24.6863;
			R30 = 58.4264;
			C10 = 6.9873e-5;
			C20 = 1.6097e-4;
			C30 = 2.6242e-7;
			alpha1 = 0.9899;
			alpha2 = 0.6430;
			alpha3 = 0.8351;
			R11 = -547.886691701476; C11 = 0.000814928145723549;
			R12 = 184649.049909962;  C12 = 0.505418088077922;
			R13 = -7133.62896778882; C13 = 0.0115229514717979;
			R14 = 404925.074612789;  C14 = 0.0684198688471808;
			R21 = -852.939431598164; C21 = -0.0136760312619277;
			R22 = 490830.617478031;  C22 = 0.500281542089184;
			R23 = -4031.86874892702; C23 = 0.0316427086016746;
			R24 = 248688.513169548;  C24 = 1.05883209263793;
			R31 = 128.171495139826;  C31 = 1.57980514770439e-05;
			R32 = 54173.8600184787;  C32 = -6.83584720004613e-06;
			R33 = -7276.19978896255; C33 = 2.15590188997655e-05;
			R34 = 402317.165441729;  C34 = -0.000762612841655925;

		end else if (IED == 25m) begin
			Rinf = 4;
			R10 = 43.9237;
			R20 = 27.5111;
			R30 = 49.1546;
			C10 = 1.1580e-4;
			C20 = 7.0e-5;
			C30 = 3.4066e-7;
			alpha1 = 0.98;
			alpha2 = 0.65;
			alpha3 = 0.84;
			R11 = 3037.86655016703;  C11 = 0.0186163348359895;
			R12 = 1371825.24070149;  C12 = -2.63708391773009;
			R13 = -4398.98785947656; C13 = 0.0210457472571047;
			R14 = 235316.233845250;  C14 = -0.167744196867776;
			R21 = 9612.81420951600;  C21 = -0.00693100776640960;
			R22 = 584181.571679630;  C22 = 0.293110929436639;
			R23 = -2821.09483279558; C23 = 0.00727463087107129;
			R24 = 162203.084286783;  C24 = -0.535274849050139;
			R31 = 3418.82374285121;  C31 = 2.97604007380933e-05;
			R32 = -170239.114655390; C32 = -0.000571683940811598;
			R33 = -4919.56065972178; C33 = 2.14699042284518e-05;
			R34 = 273408.257372143;  C34 = 0.000155752744839173;

		end else begin //40 mm IED by default
			Rinf = 5;
			R10 = 53.6034;
			R20 = 24.6863;
			R30 = 58.4264;
			C10 = 6.9873e-5;
			C20 = 1.6097e-4;
			C30 = 2.6242e-7;
			alpha1 = 0.9899;
			alpha2 = 0.6430;
			alpha3 = 0.8351;
			R11 = -547.886691701476; C11 = 0.000814928145723549;
			R12 = 184649.049909962;  C12 = 0.505418088077922;
			R13 = -7133.62896778882; C13 = 0.0115229514717979;
			R14 = 404925.074612789;  C14 = 0.0684198688471808;
			R21 = -852.939431598164; C21 = -0.0136760312619277;
			R22 = 490830.617478031;  C22 = 0.500281542089184;
			R23 = -4031.86874892702; C23 = 0.0316427086016746;
			R24 = 248688.513169548;  C24 = 1.05883209263793;
			R31 = 128.171495139826;  C31 = 1.57980514770439e-05;
			R32 = 54173.8600184787;  C32 = -6.83584720004613e-06;
			R33 = -7276.19978896255; C33 = 2.15590188997655e-05;
			R34 = 402317.165441729;  C34 = -0.000762612841655925;
		end

	end
		//Circuit Parameter scaling
		R1 = R10 + R11*(tf-tf0) + R12*pow(tf-tf0,2) + R13*(tm-tm0) + R14*pow(tm-tm0,2);
		R2 = R20 + R21*(tf-tf0) + R22*pow(tf-tf0,2) + R23*(tm-tm0) + R24*pow(tm-tm0,2);
		R3 = R30 + R31*(tf-tf0) + R32*pow(tf-tf0,2) + R33*(tm-tm0) + R34*pow(tm-tm0,2);
		C1 = C10 + C11*(tf-tf0) + C12*pow(tf-tf0,2) + C13*(tm-tm0) + C14*pow(tm-tm0,2);
		C2 = C20 + C21*(tf-tf0) + C22*pow(tf-tf0,2) + C23*(tm-tm0) + C24*pow(tm-tm0,2);
		C3 = C30 + C31*(tf-tf0) + C32*pow(tf-tf0,2) + C33*(tm-tm0) + C34*pow(tm-tm0,2);
	end

end

endmodule
