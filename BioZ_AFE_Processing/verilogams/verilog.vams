//Verilog-AMS HDL for "BioZ_EMG_Model", "BioZ_AFE_Processing" "verilogams"

`include "constants.vams"
`include "disciplines.vams"

module BioZ_AFE_Processing ( VIN_P, VIN_N, IQ_CTRL, re, im, mag, pha );

	input VIN_P, VIN_N, IQ_CTRL;
	output re, im, mag, pha;

	logic IQ_CTRL;
	electrical VIN_P, VIN_N, re, im, mag, pha;

	parameter real TCA_gain = 20u; // [I/V]
	parameter real TIA_gain = 1.5M; // [V/I]
	parameter real I_stim = 1m;

	integer sel = 0; // sel = 0 for I path, sel = 1 for Q path
	real re_buffer;
	real im_buffer;

	always@(IQ_CTRL)
	begin
		if (IQ_CTRL == 0) begin
			sel = 0;
		end else begin
			sel = 1;
		end
	end

	analog begin

		if (sel == 0) begin
			im_buffer = (`M_PI/2) * (V(VIN_P,VIN_N) / (I_stim*TCA_gain*TIA_gain));
		end else begin
			re_buffer = -(`M_PI/2) * (V(VIN_P,VIN_N) / (I_stim*TCA_gain*TIA_gain));
		end
		V(re) <+ re_buffer;
		V(im) <+ im_buffer;
		V(mag) <+ sqrt(pow(V(re),2)+pow(V(im),2));
		V(pha) <+ atan(V(im)/V(re))*(180.0/`M_PI);

	end

endmodule
