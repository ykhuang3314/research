// AMS netlist generated by the AMS Unified netlister
// IC subversion:  IC6.1.8-64b.500.7
// Xcelium version: 18.03-s018
// Copyright(C) 2005-2009, Cadence Design Systems, Inc
// User: ykhuang Pid: 5922
// Design library name: Stimulator_TestBench
// Design cell name: TB_Current_Source
// Design view name: config
// Solver: Spectre

`include "disciplines.vams"
`include "userDisciplines.vams"
// HDL file - Digital_Lib, Counter, functional.
// HDL file - Stimulator_Model, Current_Source, verilogams.
// Library - Stimulator_TestBench, Cell - TB_Current_Source, View - schematic
// LAST TIME SAVED: Jan  6 17:54:18 2021
// NETLIST TIME: Jan  6 23:16:42 2021

`worklib Stimulator_TestBench
`view schematic

`timescale 1ns / 1ps
(* cds_ams_schematic *)

module TB_Current_Source ( );
wire [4:0] count_out;
wire net3;
wire vdda;
wire net4;
wire CLK;
Current_Source I0 (.Ibias( net4 ), .Vdda( vdda ), .Vssa(cds_globals.\gnd! ), .Ioutn( net3 ), .Ioutp( vdda ), .Mag( count_out ));
Counter I1 (.out( count_out ), .CLK( CLK ), .EN( vdda ), .RESET(cds_globals.\gnd! ));
vsource #(.dc(1.8), .type("dc")) V0 (vdda, cds_globals.\gnd! );
resistor #(.r(1000)) R0 (net3, cds_globals.\gnd! );
vsource #(.type("pulse"), .val0(0), .val1(1.8), .period(0.0001), .delay(5e-05), .rise(1e-12), .fall(1e-12), .width(5e-05)) V1 (CLK, cds_globals.\gnd! );

endmodule
`noworklib
`noview
