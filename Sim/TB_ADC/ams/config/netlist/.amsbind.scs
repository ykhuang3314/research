// -----------------------------------------------------------------------------
// (c) Copyright 2010 Cadence Design Systems, Inc. All rights reserved worldwide.
// -----------------------------------------------------------------------------

// Binding AMSD Control Block for config EMG_202009.TB_ADC:config
// Created On: Sep 24 13:16:32 2020
// NOTE      : DO NOT change this system generated file.

amsd {
	config designtop="EMG_202009.TB_ADC:schematic"

	config cell="vsource" view="analogtext"
	config cell="DAC" lib="EMG_202009" view="verilogams"
	config cell="ADC" lib="EMG_202009" view="verilogams"

 }
