// AMS netlist generated by the AMS Unified netlister
// IC subversion:  IC6.1.8-64b.500.7
// Xcelium version: 18.03-s018
// Copyright(C) 2005-2009, Cadence Design Systems, Inc
// User: ykhuang Pid: 18573
// Design library name: EMG_202009
// Design cell name: TB_ADC
// Design view name: config
// Solver: Spectre

`include "disciplines.vams"
`include "userDisciplines.vams"
// HDL file - EMG_202009, DAC, verilogams.
// HDL file - EMG_202009, ADC, verilogams.
// Library - EMG_202009, Cell - TB_ADC, View - schematic
// LAST TIME SAVED: Sep 24 11:53:59 2020
// NETLIST TIME: Sep 24 13:16:30 2020

`worklib EMG_202009
`view schematic

`timescale 1ns / 1ps
(* cds_ams_schematic *)

module TB_ADC ( );
wire [0:11] Dout;
wire Vin;
wire Vdda;
wire CLK;
wire Vout;
ADC #(.thresh(0.9)) I0 (.Dout( Dout ), .Clk( CLK ), .Vdda( Vdda ), .Vin( Vin ), .Vssa(cds_globals.\gnd! ));
DAC #(.thresh(0.9)) I4 (.Vout( Vout ), .Clk( CLK ), .Din( Dout ), .Vdda( Vdda ), .Vssa(cds_globals.\gnd! ));
vsource #(.dc(0.9), .type("sine"), .ampl(0.3), .freq(500)) V0 (Vin, cds_globals.\gnd! );
vsource #(.dc(1.8), .type("dc")) V1 (Vdda, cds_globals.\gnd! );
vsource #(.type("pulse"), .val0(0), .val1(1.8), .period(1/32e+3), .delay(1/64e+3), .rise(1e-11), .fall(1e-11), .width(1/64e+3)) V2 (CLK, cds_globals.\gnd! );

endmodule
`noworklib
`noview
