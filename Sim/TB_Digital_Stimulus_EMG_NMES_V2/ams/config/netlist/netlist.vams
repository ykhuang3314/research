// AMS netlist generated by the AMS Unified netlister
// IC subversion:  IC6.1.8-64b.500.7
// Xcelium version: 18.03-s018
// Copyright(C) 2005-2009, Cadence Design Systems, Inc
// User: ykhuang Pid: 10648
// Design library name: EMG_TestBench
// Design cell name: TB_Digital_Stimulus_EMG_NMES_V2
// Design view name: config
// Solver: Spectre

`include "disciplines.vams"
`include "userDisciplines.vams"
// HDL file - EMG_Model, Digital_Stimuli_EMG_V2, functional.
// HDL file - Stimulator_Model, Digital_Stimulus_ST, functional.
// Library - EMG_TestBench, Cell - TB_Digital_Stimulus_EMG_NMES_V2, View - schematic
// LAST TIME SAVED: Feb 15 15:02:27 2021
// NETLIST TIME: Feb 15 15:02:35 2021

`worklib EMG_TestBench
`view schematic

`timescale 1ns / 1ps
(* cds_ams_schematic *)

module TB_Digital_Stimulus_EMG_NMES_V2 (ADC_CLK_EMG, ANO_ST, CAT_ST, CH_SEL_EMG, CH_SEL_ST, DIS_ST, EN_ADC_EMG, EN_ST, MAG_ST, MUX_CLK_EMG, START_EMG, CH_SWEEP_ST, ENABLE, RAMP_ST, RESET);
output  ADC_CLK_EMG, ANO_ST, CAT_ST, DIS_ST, EN_ADC_EMG, EN_ST, MUX_CLK_EMG, START_EMG;
input  CH_SWEEP_ST, ENABLE, RAMP_ST, RESET;
output [1:0] CH_SEL_ST;
output [4:0] MAG_ST;
output [3:0] CH_SEL_EMG;
Digital_Stimulus_ST I0 (.enable( ENABLE ), .ch_sweeping( CH_SWEEP_ST ), .ANO_ST( ANO_ST ), .CAT_ST( CAT_ST ), .CH_SEL_ST( CH_SEL_ST ), .DIS_ST( DIS_ST ), .EN_ST( EN_ST ), .MAG_ST( MAG_ST ), .ramping( RAMP_ST ));
Digital_Stimuli_EMG_V2 I1 (.CH_SEL_EMG( CH_SEL_EMG ), .CLK_EMG( ADC_CLK_EMG ), .EN_ADC_EMG( EN_ADC_EMG ), .MUX_CLK_EMG( MUX_CLK_EMG ), .START_EMG( START_EMG ), .Enable( ENABLE ), .RESET( RESET ));
vsource #(.dc(0), .type("dc")) V2 (RESET, cds_globals.\gnd! );
vsource #(.dc(0), .type("dc")) V1 (CH_SWEEP_ST, cds_globals.\gnd! );
vsource #(.dc(1.8), .type("dc")) V5 (RAMP_ST, cds_globals.\gnd! );
vsource #(.type("pwl"), .wave({"0", "0", "1e-05", "1.8"})) V0 (ENABLE, cds_globals.\gnd! );

endmodule
`noworklib
`noview
