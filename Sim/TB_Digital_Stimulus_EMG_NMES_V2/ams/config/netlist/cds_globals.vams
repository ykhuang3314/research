// Verilog-AMS cds_globals module for top-level cell:
//    EMG_TestBench/TB_Digital_Stimulus_EMG_NMES_V2.
// Generated by ADE.
// Cadence Design Systems, Inc.

// This is an autoGenerated file, any changes done to this file may get lost.

`include "disciplines.vams"
`include "userDisciplines.vams"

module cds_globals;

// Global Signals
   electrical \gnd! ;
   ground \gnd! ;

// Design Variables

endmodule
