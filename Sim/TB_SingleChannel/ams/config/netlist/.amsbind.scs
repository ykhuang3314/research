// -----------------------------------------------------------------------------
// (c) Copyright 2010 Cadence Design Systems, Inc. All rights reserved worldwide.
// -----------------------------------------------------------------------------

// Binding AMSD Control Block for config EMG_TestBench.TB_SingleChannel:config
// Created On: Nov 16 22:57:46 2020
// NOTE      : DO NOT change this system generated file.

amsd {
	config designtop="EMG_TestBench.TB_SingleChannel:schematic"

	config cell="vcvs" view="analogtext"
	config cell="PGA_EMG" lib="EMG_Model" view="verilogams"
	config cell="IA_EMG" lib="EMG_Model" view="verilogams"
	config cell="BPF_EMG" lib="EMG_Model" view="verilogams"
	config cell="vsource" view="analogtext"

 }
