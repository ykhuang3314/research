// AMS netlist generated by the AMS Unified netlister
// IC subversion:  IC6.1.8-64b.500.7
// Xcelium version: 18.03-s018
// Copyright(C) 2005-2009, Cadence Design Systems, Inc
// User: ykhuang Pid: 11132
// Design library name: EMG_TestBench
// Design cell name: TB_SingleChannel
// Design view name: config
// Solver: Spectre

`include "disciplines.vams"
`include "userDisciplines.vams"
// HDL file - EMG_Model, PGA_EMG, verilogams.
// HDL file - EMG_Model, BPF_EMG, verilogams.
// HDL file - EMG_Model, IA_EMG, verilogams.
// Library - EMG_TestBench, Cell - TB_SingleChannel, View - schematic
// LAST TIME SAVED: Nov 16 22:55:23 2020
// NETLIST TIME: Nov 16 22:57:44 2020

`worklib EMG_TestBench
`view schematic

`timescale 1ns / 1ps
(* cds_ams_schematic *)

module TB_SingleChannel ( );
wire [2:0] Gain_Sel;
wire Vinp;
wire Vinn;
wire Voutp_IA;
wire Voutn_IA;
wire Vdda;
wire Ibias;
wire Voutp_BPF;
wire Voutn_BPF;
wire Vout;
IA_EMG I0 (.Ibias( Ibias ), .Vdda( Vdda ), .Vssa(cds_globals.\gnd! ), .Vsub(cds_globals.\gnd! ), .Voutn( Voutn_IA ), .Voutp( Voutp_IA ), .Vinn( Vinn ), .Vinp( Vinp ));
BPF_EMG I1 (.Ibias( Ibias ), .Vdda( Vdda ), .Vssa(cds_globals.\gnd! ), .Vsub(cds_globals.\gnd! ), .Voutn( Voutn_BPF ), .Voutp( Voutp_BPF ), .Vinn( Voutn_IA ), .Vinp( Voutp_IA ));
PGA_EMG I2 (.Ibias( Ibias ), .Vdda( Vdda ), .Vssa(cds_globals.\gnd! ), .Vsub(cds_globals.\gnd! ), .Vout( Vout ), .Gain_Sel( Gain_Sel ), .Vinn( Voutn_BPF ), .Vinp( Voutp_BPF ));
vsource #(.dc(0), .type("dc")) V6 (Gain_Sel[0], cds_globals.\gnd! );
vsource #(.dc(0), .type("dc")) V5 (Gain_Sel[1], cds_globals.\gnd! );
vsource #(.dc(0), .type("dc")) V4 (Gain_Sel[2], cds_globals.\gnd! );
vsource #(.dc(0), .type("dc")) V1 (Vin_CM, cds_globals.\gnd! );
vsource #(.dc(1.8), .type("dc")) V0 (Vdda, cds_globals.\gnd! );
vsource #(.type("sine"), .ampl(0.005), .freq(100)) V2 (vsig, cds_globals.\gnd! );
vcvs #(.gain(0.5)) E1 (Vinp, Vin_CM, vsig, cds_globals.\gnd! );
vcvs #(.gain(-0.5)) E0 (Vinn, Vin_CM, vsig, cds_globals.\gnd! );

endmodule
`noworklib
`noview
