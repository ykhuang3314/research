// Design: Stimulator_TestBench/TB_LS_LowSide
simulator lang=spectre
global 0
include "/pkg/xfab/XKIT/xh018/cadence/v8_0/spectre/v8_0_1/lpmos/config.scs" section=default
include "/pkg/xfab/XKIT/xh018/cadence/v8_0/spectre/v8_0_1/lpmos/param.scs" section=3s
include "/pkg/xfab/XKIT/xh018/cadence/v8_0/spectre/v8_0_1/lpmos/bip.scs" section=tm
include "/pkg/xfab/XKIT/xh018/cadence/v8_0/spectre/v8_0_1/lpmos/cap.scs" section=tm
include "/pkg/xfab/XKIT/xh018/cadence/v8_0/spectre/v8_0_1/lpmos/dio.scs" section=tm
include "/pkg/xfab/XKIT/xh018/cadence/v8_0/spectre/v8_0_1/lpmos/mos.scs" section=tm
include "/pkg/xfab/XKIT/xh018/cadence/v8_0/spectre/v8_0_1/lpmos/photo.scs" section=tm
include "/pkg/xfab/XKIT/xh018/cadence/v8_0/spectre/v8_0_1/lpmos/res.scs" section=tm

// Stimulator_IMP/INV3_ST/schematic
subckt INV3_ST in out vdd3 vss
parameters W=2u
    M1 (out in vdd3 vdd3) pe3 w=2*W l=300n m=(1)*(1)
    M0 (out in vss vss) ne3 w=W l=350.0n m=(1)*(1)
ends INV3_ST

// Stimulator_IMP/LS_LowSide_ST/schematic
subckt LS_LowSide_ST in out vdd10 vdd3 vss
    I8 (IN3 IN3_n vdd3 vss) INV3_ST W=2u
    I1 (in IN3 vdd3 vss) INV3_ST W=2u
    M3 (outn out vdd10 vdd10 0) pmma_bjt w=5u l=2.9u m=(1)*(1)
    M2 (out outn vdd10 vdd10 0) pmma_bjt w=5u l=2.9u m=(1)*(1)
    M9 (out IN3_n vss vss) nmma_bjt w=15.0u l=2.9u m=(1)*(1)
    M8 (outn IN3 vss vss) nmma_bjt w=15.0u l=2.9u m=(1)*(1)
ends LS_LowSide_ST

// Stimulator_TestBench/TB_LS_LowSide/schematic
I0 (in out net2 net3 0) LS_LowSide_ST
V1 (net2 0) vsource dc=10 type=dc
V0 (net3 0) vsource dc=3.3 type=dc
V2 (in 0) vsource type=pulse val0=0 val1=1.8 period=100u delay=50u rise=1p fall=1p width=50u
C0 (out 0) capacitor c=1p
simulatorOptions options reltol=100e-6 temp=27 homotopy=all limit=delta compatible=spice2
tran tran stop=500u errpreset=conservative
