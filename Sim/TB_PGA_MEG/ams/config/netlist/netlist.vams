// AMS netlist generated by the AMS Unified netlister
// IC subversion:  IC6.1.8-64b.500.7
// Xcelium version: 18.03-s018
// Copyright(C) 2005-2009, Cadence Design Systems, Inc
// User: ykhuang Pid: 11132
// Design library name: EMG_TestBench
// Design cell name: TB_PGA_MEG
// Design view name: config
// Solver: Spectre

`include "disciplines.vams"
`include "userDisciplines.vams"
// HDL file - EMG_Model, PGA_EMG, verilogams.
// Library - EMG_TestBench, Cell - TB_PGA_MEG, View - schematic
// LAST TIME SAVED: Nov 16 22:31:00 2020
// NETLIST TIME: Nov 16 22:32:55 2020

`worklib EMG_TestBench
`view schematic

`timescale 1ns / 1ps
(* cds_ams_schematic *)

module TB_PGA_MEG ( );
wire [2:0] Gain_Sel;
wire net8;
wire net7;
wire Vout;
wire Vdda;
wire net9;
PGA_EMG I0 (.Ibias( net9 ), .Vdda( Vdda ), .Vssa(cds_globals.\gnd! ), .Vsub(cds_globals.\gnd! ), .Vout( Vout ), .Gain_Sel( Gain_Sel ), .Vinn( net7 ), .Vinp( net8 ));
vsource #(.dc(0), .type("dc")) V6 (Gain_Sel[0], cds_globals.\gnd! );
vsource #(.dc(0), .type("dc")) V5 (Gain_Sel[1], cds_globals.\gnd! );
vsource #(.dc(0), .type("dc")) V4 (Gain_Sel[2], cds_globals.\gnd! );
vsource #(.dc(0), .type("dc")) V1 (Vin_CM, cds_globals.\gnd! );
vsource #(.dc(1.8), .type("dc")) V0 (Vdda, cds_globals.\gnd! );
vsource #(.mag(0), .type("sine"), .ampl(0.2), .freq(100)) V2 (vsig, cds_globals.\gnd! );
vcvs #(.gain(-0.5)) E1 (net8, Vin_CM, vsig, cds_globals.\gnd! );
vcvs #(.gain(0.5)) E0 (net7, Vin_CM, vsig, cds_globals.\gnd! );
isource #(.type("dc")) I1 (Vdda, net9);

endmodule
`noworklib
`noview
