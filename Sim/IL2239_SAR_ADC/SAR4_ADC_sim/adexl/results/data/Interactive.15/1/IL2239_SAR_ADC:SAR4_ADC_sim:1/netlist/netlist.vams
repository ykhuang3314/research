// AMS netlist generated by the AMS Unified netlister
// IC subversion:  IC6.1.8-64b.500.7
// Xcelium version: 18.03-s018
// Copyright(C) 2005-2009, Cadence Design Systems, Inc
// User: ykhuang Pid: 13526
// Design library name: IL2239_SAR_ADC
// Design cell name: SAR4_ADC_sim
// Design view name: config
// Solver: Spectre

`include "disciplines.vams"
`include "userDisciplines.vams"
// HDL file - IL2239_SAR_ADC, SAR4, verilogams.
// HDL file - IL2239_SAR_ADC, comp_v2, verilogams.
// HDL file - IL2239_SAR_ADC, relay, verilogams.
// Library - IL2239_SAR_ADC, Cell - inverterX2, View - schematic
// LAST TIME SAVED: Apr 14 16:41:16 2021
// NETLIST TIME: Apr 14 23:15:19 2021

`worklib IL2239_SAR_ADC
`view schematic

`timescale 1ns / 1ps
(* cds_ams_schematic *)

module inverterX2 (out, VDD, VSS, in);
output  out;
input  in;
inout  VDD, VSS;
pel #(.w(1.74e-06), .l(1.8e-07), .as(8.352e-13), .ad(8.352e-13), .ps(4.44e-06), .pd(4.44e-06), .nrs(0.155172), .nrd(0.155172), .m((2)*(1)), .par1((2)*(1)))
(* integer passed_mfactor = "m"; *)
 M0 (out, in, VDD, VDD);
nel #(.w(1.2e-06), .l(1.8e-07), .as(5.76e-13), .ad(5.76e-13), .ps(3.36e-06), .pd(3.36e-06), .nrs(0.225), .nrd(0.225), .m((2)*(1)), .par1((2)*(1)), .xf_subext(0))
(* integer passed_mfactor = "m"; *)
 M1 (out, in, VSS, VSS);

endmodule
// Library - IL2239_SAR_ADC, Cell - DAC4_SH, View - schematic
// LAST TIME SAVED: Apr 14 23:04:17 2021
// NETLIST TIME: Apr 14 23:15:19 2021

`worklib IL2239_SAR_ADC
`view schematic

`timescale 1ns / 1ps
(* cds_ams_schematic *)

module DAC4_SH (outp, CM, REF, SW_inp, SW_ref, VSS, b0, b1, b2, b3, inp);
output  outp;
input  CM, REF, SW_inp, SW_ref, VSS, b0, b1, b2, b3, inp;
wire net055;
wire net85;
wire c1;
wire b0n;
wire c2;
wire b1n;
wire c4;
wire b2n;
wire c8;
wire b3n;
wire VDD;
relay #(.Ron(cds_globals.Ron), .Roff(cds_globals.Roff)) I21 (.in( net85 ), .out( net055 ), .gate( SW_inp ));
relay #(.Ron(cds_globals.Ron), .Roff(cds_globals.Roff)) I20 (.in( VSS ), .out( net055 ), .gate( SW_ref ));
relay #(.Ron(cds_globals.Ron), .Roff(cds_globals.Roff)) I10 (.in( inp ), .out( net85 ), .gate( SW_inp ));
relay #(.Ron(cds_globals.Ron), .Roff(cds_globals.Roff)) I9 (.in( REF ), .out( net85 ), .gate( SW_ref ));
relay #(.Ron(cds_globals.Ron), .Roff(cds_globals.Roff)) I8 (.in( CM ), .out( outp ), .gate( SW_inp ));
relay #(.Ron(cds_globals.Ron), .Roff(cds_globals.Roff)) I7 (.in( net85 ), .out( c1 ), .gate( b1 ));
relay #(.Ron(cds_globals.Ron), .Roff(cds_globals.Roff)) I6 (.in( VSS ), .out( c1 ), .gate( b0n ));
relay #(.Ron(cds_globals.Ron), .Roff(cds_globals.Roff)) I5 (.in( net85 ), .out( c2 ), .gate( b1 ));
relay #(.Ron(cds_globals.Ron), .Roff(cds_globals.Roff)) I4 (.in( VSS ), .out( c2 ), .gate( b1n ));
relay #(.Ron(cds_globals.Ron), .Roff(cds_globals.Roff)) I3 (.in( net85 ), .out( c4 ), .gate( b2 ));
relay #(.Ron(cds_globals.Ron), .Roff(cds_globals.Roff)) I2 (.in( VSS ), .out( c4 ), .gate( b2n ));
relay #(.Ron(cds_globals.Ron), .Roff(cds_globals.Roff)) I1 (.in( net85 ), .out( c8 ), .gate( b3 ));
relay #(.Ron(cds_globals.Ron), .Roff(cds_globals.Roff)) I0 (.in( VSS ), .out( c8 ), .gate( b3n ));
inverterX2 I17 (.VSS( VSS ), .VDD( VDD ), .out( b3n ), .in( b3 ));
inverterX2 I16 (.VSS( VSS ), .VDD( VDD ), .out( b1n ), .in( b1 ));
inverterX2 I13 (.VSS( VSS ), .VDD( VDD ), .out( b2n ), .in( b2 ));
inverterX2 I11 (.VSS( VSS ), .VDD( VDD ), .out( b0n ), .in( b0 ));
capacitor #(.c(cds_globals.Cap+cds_globals.dCap)) C30 (outp, net055);
capacitor #(.c(cds_globals.Cchannel/2)) C29 (net055, SW_inp);
capacitor #(.c(cds_globals.Cchannel/2)) C28 (net055, SW_ref);
capacitor #(.c(cds_globals.Cchannel/2)) C27 (net85, SW_inp);
capacitor #(.c(cds_globals.Cchannel/2)) C26 (VSS, SW_ref);
capacitor #(.c(cds_globals.Cchannel/2)) C25 (inp, SW_inp);
capacitor #(.c(cds_globals.Cchannel/2)) C24 (net85, SW_inp);
capacitor #(.c(cds_globals.Cchannel/2)) C23 (REF, SW_ref);
capacitor #(.c(cds_globals.Cchannel/2)) C22 (net85, SW_ref);
capacitor #(.c(cds_globals.Cchannel/2)) C21 (CM, SW_inp);
capacitor #(.c(cds_globals.Cchannel/2)) C20 (outp, SW_inp);
capacitor #(.c(cds_globals.Cap+cds_globals.dCap)) C19 (outp, c1);
capacitor #(.c(cds_globals.Cchannel/2)) C18 (net85, b1);
capacitor #(.c(cds_globals.Cchannel/2)) C17 (c1, b1);
capacitor #(.c(cds_globals.Cchannel/2)) C16 (VSS, b0n);
capacitor #(.c(cds_globals.Cchannel/2)) C15 (c1, b0n);
capacitor #(.c(2*cds_globals.Cap+2*cds_globals.dCap)) C14 (outp, c2);
capacitor #(.c(cds_globals.Cchannel/2)) C13 (net85, b1);
capacitor #(.c(cds_globals.Cchannel/2)) C12 (c2, b1);
capacitor #(.c(cds_globals.Cchannel/2)) C11 (VSS, b1n);
capacitor #(.c(cds_globals.Cchannel/2)) C10 (c2, b1n);
capacitor #(.c(4*cds_globals.Cap+4*cds_globals.dCap)) C9 (outp, c4);
capacitor #(.c(cds_globals.Cchannel/2)) C8 (net85, b2);
capacitor #(.c(cds_globals.Cchannel/2)) C7 (c4, b2);
capacitor #(.c(cds_globals.Cchannel/2)) C6 (VSS, b2n);
capacitor #(.c(cds_globals.Cchannel/2)) C5 (c4, b2n);
capacitor #(.c(8*cds_globals.Cap+8*cds_globals.dCap)) C4 (outp, c8);
capacitor #(.c(cds_globals.Cchannel/2)) C3 (net85, b3);
capacitor #(.c(cds_globals.Cchannel/2)) C2 (c8, b3);
capacitor #(.c(cds_globals.Cchannel/2)) C1 (VSS, b3n);
capacitor #(.c(cds_globals.Cchannel/2)) C0 (c8, b3n);
vsource #(.dc(1.8), .type("dc")) V0 (VDD, cds_globals.\gnd! );

endmodule
// Library - IL2239_SAR_ADC, Cell - bufferX2, View - schematic
// LAST TIME SAVED: Apr 14 16:43:14 2021
// NETLIST TIME: Apr 14 23:15:19 2021

`worklib IL2239_SAR_ADC
`view schematic

`timescale 1ns / 1ps
(* cds_ams_schematic *)

module bufferX2 (out, VDD, VSS, in);
output  out;
input  in;
inout  VDD, VSS;
pel #(.w(1.74e-06), .l(1.8e-07), .as(8.352e-13), .ad(8.352e-13), .ps(4.44e-06), .pd(4.44e-06), .nrs(0.155172), .nrd(0.155172), .m((2)*(1)), .par1((2)*(1)))
(* integer passed_mfactor = "m"; *)
 M0 (out, net44, VDD, VDD);
pel #(.w(1.74e-06), .l(1.8e-07), .as(8.352e-13), .ad(8.352e-13), .ps(4.44e-06), .pd(4.44e-06), .nrs(0.155172), .nrd(0.155172), .m((1)*(1)), .par1((1)*(1)))
(* integer passed_mfactor = "m"; *)
 M2 (net44, in, VDD, VDD);
nel #(.w(1.2e-06), .l(1.8e-07), .as(5.76e-13), .ad(5.76e-13), .ps(3.36e-06), .pd(3.36e-06), .nrs(0.225), .nrd(0.225), .m((1)*(1)), .par1((1)*(1)), .xf_subext(0))
(* integer passed_mfactor = "m"; *)
 M3 (net44, in, VSS, VSS);
nel #(.w(1.2e-06), .l(1.8e-07), .as(5.76e-13), .ad(5.76e-13), .ps(3.36e-06), .pd(3.36e-06), .nrs(0.225), .nrd(0.225), .m((2)*(1)), .par1((2)*(1)), .xf_subext(0))
(* integer passed_mfactor = "m"; *)
 M1 (out, net44, VSS, VSS);

endmodule
// Library - IL2239_SAR_ADC, Cell - SAR4_ADC_sim, View - schematic
// LAST TIME SAVED: Apr 14 23:09:53 2021
// NETLIST TIME: Apr 14 23:15:19 2021

`worklib IL2239_SAR_ADC
`view schematic

`timescale 1ns / 1ps
(* cds_ams_schematic *)

module SAR4_ADC_sim ( );
wire Vin;
wire SW_ref;
wire SW_inp;
wire DAC_out3;
wire DAC_out2;
wire DAC_out1;
wire DAC_out0;
wire DAC_analog;
wire Vcm;
wire Vref;
wire net3;
wire CLK;
wire VDD;
wire comp;
wire outn;
wire out3;
wire out2;
wire out1;
wire out0;
wire eoc;
DAC4_SH I1 (.VSS(cds_globals.\gnd! ), .REF( Vref ), .CM( Vcm ), .outp( DAC_analog ), .b0( DAC_out0 ), .b1( DAC_out1 ), .b2( DAC_out2 ), .b3( DAC_out3 ), .SW_inp( SW_inp ), .SW_ref( SW_ref ), .inp( Vin ));
bufferX2 I16 (.VSS(cds_globals.\gnd! ), .VDD( VDD ), .out( CLK ), .in( net3 ));
comp_v2 I18 (.VSS(cds_globals.\gnd! ), .CLK( CLK ), .VDD( VDD ), .outn( outn ), .outp( comp ), .in1( DAC_analog ), .in2( Vcm ));
SAR4 I0 (.DAC_out0( DAC_out0 ), .DAC_out1( DAC_out1 ), .DAC_out2( DAC_out2 ), .DAC_out3( DAC_out3 ), .SW_inp( SW_inp ), .SW_ref( SW_ref ), .eoc( eoc ), .out0( out0 ), .out1( out1 ), .out2( out2 ), .out3( out3 ), .clock( CLK ), .comp( comp ), .reset(cds_globals.\gnd! ), .start( VDD ));
vsource #(.dc(cds_globals.Vref), .type("dc")) V3 (Vref, cds_globals.\gnd! );
vsource #(.dc(cds_globals.Vcm), .type("dc")) V2 (Vcm, cds_globals.\gnd! );
vsource #(.dc(cds_globals.VDD), .type("dc")) V1 (VDD, cds_globals.\gnd! );
vsource #(.type("pulse"), .val0(0), .val1(1.8), .period(1/cds_globals.fclk), .rise(0.001/cds_globals.fclk), .fall(0.001/cds_globals.fclk), .width(0.5/cds_globals.fclk)) V4 (net3, cds_globals.\gnd! );
vsource #(.type("pulse"), .val0(0), .val1(0.4), .period(0.0001256), .rise(2.08e-05), .fall(2.08e-05), .width(6.28e-05)) V0 (Vin, cds_globals.\gnd! );

endmodule
`noworklib
`noview
