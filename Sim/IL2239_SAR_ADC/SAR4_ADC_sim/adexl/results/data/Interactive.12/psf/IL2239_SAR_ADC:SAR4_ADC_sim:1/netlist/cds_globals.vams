// Verilog-AMS cds_globals module for top-level cell:
//    IL2239_SAR_ADC/SAR4_ADC_sim.
// Generated by ADE.
// Cadence Design Systems, Inc.

// This is an autoGenerated file, any changes done to this file may get lost.

`include "disciplines.vams"
`include "userDisciplines.vams"

module cds_globals;

// Global Signals
   electrical \gnd! ;
   ground \gnd! ;

// Design Variables
   dynamicparam real fin = 437500;
   dynamicparam real Roff = 500M;
   dynamicparam real Ron = 140;
   dynamicparam real Cap = 25f;
   dynamicparam real Cchannel = 15f;
   dynamicparam real dCap = 0;
   dynamicparam real fclk = 20M;
   dynamicparam real Vcm = 200m;
   dynamicparam real VDD = 1.8;
   dynamicparam real Vin = 180m;
   dynamicparam real Vref = 400m;

endmodule
