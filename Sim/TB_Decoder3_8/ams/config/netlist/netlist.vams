// AMS netlist generated by the AMS Unified netlister
// IC subversion:  IC6.1.8-64b.500.7
// Xcelium version: 18.03-s018
// Copyright(C) 2005-2009, Cadence Design Systems, Inc
// User: ykhuang Pid: 5609
// Design library name: Stimulator_TestBench
// Design cell name: TB_Decoder3_8
// Design view name: config
// Solver: Spectre

`include "disciplines.vams"
`include "userDisciplines.vams"
// HDL file - Digital_Lib, Counter, functional.
// HDL file - Stimulator_IMP, Decoder3_8, functional.
// Library - Stimulator_TestBench, Cell - TB_Decoder3_8, View - schematic
// LAST TIME SAVED: Apr  1 15:15:33 2021
// NETLIST TIME: Apr  1 15:17:46 2021

`worklib Stimulator_TestBench
`view schematic

`timescale 1ns / 1ps
(* cds_ams_schematic *)

module TB_Decoder3_8 ( );
wire [7:0] Dout;
wire [2:0] Bin;
wire net4;
wire net3;
wire CLK;
Decoder3_8 I0 (.Dout( Dout ), .Bin( Bin ), .Enable( net4 ));
Counter I2 (.out( Bin ), .CLK( CLK ), .EN( net3 ), .RESET(cds_globals.\gnd! ));
vsource #(.dc(1.8), .type("dc")) V1 (net3, cds_globals.\gnd! );
vsource #(.dc(1.8), .type("dc")) V0 (net4, cds_globals.\gnd! );
vsource #(.type("pulse"), .val0(0), .val1(1.8), .period(0.0001), .delay(5e-05), .rise(1e-12), .fall(1e-12), .width(5e-05)) V2 (CLK, cds_globals.\gnd! );

endmodule
`noworklib
`noview
