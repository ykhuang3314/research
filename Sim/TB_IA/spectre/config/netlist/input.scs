// Generated for: spectre
// Generated on: Sep 21 13:42:27 2020
// Design library name: EMG_202009
// Design cell name: TB_IA
// Design view name: config
simulator lang=spectre
global 0
include "/pkg/xfab/XKIT/xh018/cadence/v8_0/spectre/v8_0_1/lpmos/config.scs" section=default
include "/pkg/xfab/XKIT/xh018/cadence/v8_0/spectre/v8_0_1/lpmos/param.scs" section=3s
include "/pkg/xfab/XKIT/xh018/cadence/v8_0/spectre/v8_0_1/lpmos/bip.scs" section=tm
include "/pkg/xfab/XKIT/xh018/cadence/v8_0/spectre/v8_0_1/lpmos/cap.scs" section=tm
include "/pkg/xfab/XKIT/xh018/cadence/v8_0/spectre/v8_0_1/lpmos/dio.scs" section=tm
include "/pkg/xfab/XKIT/xh018/cadence/v8_0/spectre/v8_0_1/lpmos/mos.scs" section=tm
include "/pkg/xfab/XKIT/xh018/cadence/v8_0/spectre/v8_0_1/lpmos/photo.scs" section=tm
include "/pkg/xfab/XKIT/xh018/cadence/v8_0/spectre/v8_0_1/lpmos/res.scs" section=tm

// Library name: EMG_202009
// Cell name: TB_IA
// View name: schematic
// Inherited view list: spectre cmos_sch cmos.sch schematic veriloga ahdl
// pspice dspf verilogams
I0 (Voutp Voutn net8 net9 Vdda 0) IA Vcm=0.9 Gain=25
V1 (Vin_CM 0) vsource dc=0 type=dc
V0 (Vdda 0) vsource dc=1.8 type=dc
E1 (net9 Vin_CM vsig 0) vcvs gain=-0.5
E0 (net8 Vin_CM vsig 0) vcvs gain=0.5
V2 (vsig 0) vsource mag=10m type=sine freq=100
simulatorOptions options psfversion="1.1.0" reltol=100e-6 vabstol=1e-6 \
    iabstol=1e-12 temp=27 tnom=27 homotopy=all limit=delta scalem=1.0 \
    scale=1.0 compatible=spice2 gmin=1e-12 rforce=1 maxnotes=5 maxwarns=5 \
    digits=5 cols=80 pivrel=1e-3 sensfile="../psf/sens.output" \
    checklimitdest=psf
tran tran stop=1 errpreset=liberal write="spectre.ic" \
    writefinal="spectre.fc" annotate=status maxiters=5
finalTimeOP info what=oppoint where=rawfile
modelParameter info what=models where=rawfile
element info what=inst where=rawfile
outputParameter info what=output where=rawfile
designParamVals info what=parameters where=rawfile
primitives info what=primitives where=rawfile
subckts info what=subckts where=rawfile
saveOptions options save=allpub
