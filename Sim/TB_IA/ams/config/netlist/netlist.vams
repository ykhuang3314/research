// AMS netlist generated by the AMS Unified netlister
// IC subversion:  IC6.1.8-64b.500.7
// Xcelium version: 18.03-s018
// Copyright(C) 2005-2009, Cadence Design Systems, Inc
// User: ykhuang Pid: 12361
// Design library name: EMG_202009
// Design cell name: TB_IA
// Design view name: config
// Solver: Spectre

`include "disciplines.vams"
`include "userDisciplines.vams"
// HDL file - EMG_202009, IA, verilogams.
// Library - EMG_202009, Cell - TB_IA, View - schematic
// LAST TIME SAVED: Sep 27 23:45:48 2020
// NETLIST TIME: Sep 27 23:47:45 2020

`worklib EMG_202009
`view schematic

`timescale 1ns / 1ps
(* cds_ams_schematic *)

module TB_IA ( );
wire net8;
wire net9;
wire Vdda;
wire Vout;
IA I0 (.Vout( Vout ), .Vdda( Vdda ), .Vinn( net9 ), .Vinp( net8 ), .Vssa(cds_globals.\gnd! ));
vsource #(.dc(0), .type("dc")) V1 (Vin_CM, cds_globals.\gnd! );
vsource #(.dc(1.8), .type("dc")) V0 (Vdda, cds_globals.\gnd! );
vcvs #(.gain(-0.5)) E1 (net9, Vin_CM, vsig, cds_globals.\gnd! );
vcvs #(.gain(0.5)) E0 (net8, Vin_CM, vsig, cds_globals.\gnd! );
vsource #(.type("sine"), .ampl(0.005), .freq(100)) V2 (vsig, cds_globals.\gnd! );

endmodule
`noworklib
`noview
