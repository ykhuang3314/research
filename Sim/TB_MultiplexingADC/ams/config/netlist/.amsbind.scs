// -----------------------------------------------------------------------------
// (c) Copyright 2010 Cadence Design Systems, Inc. All rights reserved worldwide.
// -----------------------------------------------------------------------------

// Binding AMSD Control Block for config EMG_202009.TB_MultiplexingADC:config
// Created On: Sep 29 00:13:12 2020
// NOTE      : DO NOT change this system generated file.

amsd {
	config designtop="EMG_202009.TB_MultiplexingADC:schematic"

	config cell="vsource" view="analogtext"
	config cell="DAC" lib="EMG_202009" view="verilogams"
	config cell="Counter_4bit" lib="EMG_202009" view="functional"
	config cell="ADC" lib="EMG_202009" view="verilogams"
	config cell="MUX_16" lib="EMG_202009" view="verilogams"

 }
