// AMS netlist generated by the AMS Unified netlister
// IC subversion:  IC6.1.8-64b.500.7
// Xcelium version: 18.03-s018
// Copyright(C) 2005-2009, Cadence Design Systems, Inc
// User: ykhuang Pid: 5305
// Design library name: Stimulator_TestBench
// Design cell name: TB_Multi_CH
// Design view name: config
// Solver: Spectre

`include "disciplines.vams"
`include "userDisciplines.vams"
// HDL file - Stimulator_Model, CH_Sel_MUX, verilogams.
// HDL file - Stimulator_Model, H_Bridge, verilogams.
// HDL file - Stimulator_Model, Current_Mirror, verilogams.
// HDL file - Stimulator_Model, Current_Source, verilogams.
// Library - Stimulator_TestBench, Cell - TB_Multi_CH, View - schematic
// LAST TIME SAVED: Jan 21 14:00:27 2021
// NETLIST TIME: Jan 21 14:14:16 2021

`worklib Stimulator_TestBench
`view schematic

`timescale 1ns / 1ps
(* cds_ams_schematic *)

module TB_Multi_CH ( );
wire [4:0] Mag;
wire [1:0] CH_SEL;
wire net33;
wire Vssa;
wire Vdda;
wire net23;
wire net24;
wire DIS;
wire CAT;
wire ANO;
wire net14;
wire net29;
wire VddH;
wire net27;
wire net18;
wire net31;
wire net28;
wire net10;
wire net22;
wire net25;
wire net6;
wire net19;
wire net20;
Current_Source I10 (.Ibias( net23 ), .Vdda( Vdda ), .Vssa( Vssa ), .Ioutn( net33 ), .Ioutp( Vdda ), .Mag( Mag ));
Current_Mirror I2 (.Iref( net33 ), .Iout( net24 ), .Vdda( Vdda ), .Vssa( Vssa ));
H_Bridge I4 (.Ist( net27 ), .VddH( VddH ), .Vdda( Vdda ), .Vssa( Vssa ), .Iano( net29 ), .Icat( net14 ), .ANO( ANO ), .CAT( CAT ), .DIS( DIS ));
H_Bridge I1 (.Ist( net28 ), .VddH( VddH ), .Vdda( Vdda ), .Vssa( Vssa ), .Iano( net31 ), .Icat( net18 ), .ANO( ANO ), .CAT( CAT ), .DIS( DIS ));
H_Bridge I0 (.Ist( net25 ), .VddH( VddH ), .Vdda( Vdda ), .Vssa( Vssa ), .Iano( net22 ), .Icat( net10 ), .ANO( ANO ), .CAT( CAT ), .DIS( DIS ));
H_Bridge I3 (.Ist( net20 ), .VddH( VddH ), .Vdda( Vdda ), .Vssa( Vssa ), .Iano( net19 ), .Icat( net6 ), .ANO( ANO ), .CAT( CAT ), .DIS( DIS ));
CH_Sel_MUX I6 (.Vdda( Vdda ), .Vssa( Vssa ), .Ist_ch1( net20 ), .Ist_ch2( net25 ), .Ist_ch3( net27 ), .Ist_ch4( net28 ), .CH_SEL( CH_SEL ), .Ist( net24 ));
vsource #(.dc(0), .type("dc")) V13 (Mag[0], cds_globals.\gnd! );
vsource #(.dc(1.8), .type("dc")) V12 (Mag[1], cds_globals.\gnd! );
vsource #(.dc(0), .type("dc")) V11 (Mag[2], cds_globals.\gnd! );
vsource #(.dc(1.8), .type("dc")) V10 (Mag[3], cds_globals.\gnd! );
vsource #(.dc(0), .type("dc")) V7 (Mag[4], cds_globals.\gnd! );
vsource #(.dc(0), .type("dc")) V6 (Vssa, cds_globals.\gnd! );
vsource #(.dc(1.8), .type("dc")) V2 (Vdda, cds_globals.\gnd! );
vsource #(.dc(30), .type("dc")) V1 (VddH, cds_globals.\gnd! );
vsource #(.dc(0), .type("dc")) V5 (DIS, cds_globals.\gnd! );
vsource #(.type("pulse"), .val0(0), .val1(1.8), .period(0.0022), .delay(0.0011), .rise(1e-12), .fall(1e-12), .width(0.0011)) V8 (CH_SEL[0], cds_globals.\gnd! );
vsource #(.type("pulse"), .val0(0), .val1(1.8), .period(0.0044), .delay(0.0022), .rise(1e-12), .fall(1e-12), .width(0.0022)) V9 (CH_SEL[1], cds_globals.\gnd! );
vsource #(.type("pulse"), .val0(0), .val1(1.8), .period(0.00022), .delay(1e-05), .rise(1e-12), .fall(1e-12), .width(0.0001)) V0 (ANO, cds_globals.\gnd! );
vsource #(.type("pulse"), .val0(0), .val1(1.8), .period(0.00022), .delay(0.00012), .rise(1e-12), .fall(1e-12), .width(0.0001)) V3 (CAT, cds_globals.\gnd! );
isource #(.dc(1e-05), .type("dc")) I11 (Vdda, net23);
resistor #(.r(1000000)) R11 (net14, net13);
resistor #(.r(500)) R10 (net12, net13);
resistor #(.r(1000000)) R9 (net29, net12);
resistor #(.r(1000000)) R8 (net18, net17);
resistor #(.r(500)) R7 (net16, net17);
resistor #(.r(1000000)) R6 (net31, net16);
resistor #(.r(1000000)) R2 (net10, net9);
resistor #(.r(500)) R1 (net8, net9);
resistor #(.r(1000000)) R0 (net22, net8);
resistor #(.r(1000000)) R5 (net6, net5);
resistor #(.r(500)) R4 (net4, net5);
resistor #(.r(1000000)) R3 (net19, net4);
capacitor #(.c(1e-09)) C7 (net14, net13);
capacitor #(.c(1e-09)) C6 (net29, net12);
capacitor #(.c(1e-09)) C5 (net18, net17);
capacitor #(.c(1e-09)) C4 (net31, net16);
capacitor #(.c(1e-09)) C1 (net10, net9);
capacitor #(.c(1e-09)) C0 (net22, net8);
capacitor #(.c(1e-09)) C3 (net6, net5);
capacitor #(.c(1e-09)) C2 (net19, net4);

endmodule
`noworklib
`noview
