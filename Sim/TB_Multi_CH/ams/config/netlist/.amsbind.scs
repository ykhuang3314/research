// -----------------------------------------------------------------------------
// (c) Copyright 2010 Cadence Design Systems, Inc. All rights reserved worldwide.
// -----------------------------------------------------------------------------

// Binding AMSD Control Block for config Stimulator_TestBench.TB_Multi_CH:config
// Created On: Jan 21 14:14:18 2021
// NOTE      : DO NOT change this system generated file.

amsd {
	config designtop="Stimulator_TestBench.TB_Multi_CH:schematic"

	config cell="CH_Sel_MUX" lib="Stimulator_Model" view="verilogams"
	config cell="Current_Source" lib="Stimulator_Model" view="verilogams"
	config cell="Current_Mirror" lib="Stimulator_Model" view="verilogams"
	config cell="capacitor" view="analogtext"
	config cell="isource" view="analogtext"
	config cell="vsource" view="analogtext"
	config cell="resistor" view="analogtext"
	config cell="H_Bridge" lib="Stimulator_Model" view="verilogams"

 }
