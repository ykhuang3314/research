// AMS netlist generated by the AMS Unified netlister
// IC subversion:  IC6.1.8-64b.500.7
// Xcelium version: 18.03-s018
// Copyright(C) 2005-2009, Cadence Design Systems, Inc
// User: ykhuang Pid: 10648
// Design library name: Stimulator_TestBench
// Design cell name: Digital_Stimulus_TB
// Design view name: config
// Solver: Spectre

`include "disciplines.vams"
`include "userDisciplines.vams"
// HDL file - Stimulator_Model, Digital_Stimulus_ST, functional.
// Library - Stimulator_TestBench, Cell - Digital_Stimulus_TB, View - schematic
// LAST TIME SAVED: Feb 15 22:10:37 2021
// NETLIST TIME: Feb 15 22:14:54 2021

`worklib Stimulator_TestBench
`view schematic

`timescale 1ns / 1ps
(* cds_ams_schematic *)

module Digital_Stimulus_TB ( );
wire [4:0] MAG;
wire [1:0] CH_SEL;
wire net08;
wire EN;
wire DIS;
wire CAT;
wire ANO;
wire net02;
wire net03;
Digital_Stimulus_ST I7 (.enable( net03 ), .ch_sweeping( net02 ), .ANO_ST( ANO ), .CAT_ST( CAT ), .CH_SEL_ST( CH_SEL ), .DIS_ST( DIS ), .EN_ST( EN ), .MAG_ST( MAG ), .ramping( net08 ));
vsource #(.type("pwl"), .wave({"0", "0", "1e-05", "1.8"})) V0 (net03, cds_globals.\gnd! );
vsource #(.dc(1.8), .type("dc")) V2 (net08, cds_globals.\gnd! );
vsource #(.dc(0), .type("dc")) V1 (net02, cds_globals.\gnd! );

endmodule
`noworklib
`noview
