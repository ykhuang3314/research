// -----------------------------------------------------------------------------
// (c) Copyright 2010 Cadence Design Systems, Inc. All rights reserved worldwide.
// -----------------------------------------------------------------------------

// Binding AMSD Control Block for config Stimulator_TestBench.Digital_Stimulus_TB:config
// Created On: Feb 15 22:14:56 2021
// NOTE      : DO NOT change this system generated file.

amsd {
	config designtop="Stimulator_TestBench.Digital_Stimulus_TB:schematic"

	config cell="Digital_Stimulus_ST" lib="Stimulator_Model" view="functional"
	config cell="vsource" view="analogtext"

 }
