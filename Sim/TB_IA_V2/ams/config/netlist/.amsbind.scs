// -----------------------------------------------------------------------------
// (c) Copyright 2010 Cadence Design Systems, Inc. All rights reserved worldwide.
// -----------------------------------------------------------------------------

// Binding AMSD Control Block for config EMG_TestBench.TB_IA_V2:config
// Created On: Nov 17 23:50:10 2020
// NOTE      : DO NOT change this system generated file.

amsd {
	config designtop="EMG_TestBench.TB_IA_V2:schematic"

	config cell="vcvs" view="analogtext"
	config cell="IA_EMG_V2" lib="EMG_Model" view="verilogams"
	config cell="isource" view="analogtext"
	config cell="vsource" view="analogtext"

 }
