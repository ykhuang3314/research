// AMS netlist generated by the AMS Unified netlister
// IC subversion:  IC6.1.8-64b.500.7
// Xcelium version: 18.03-s018
// Copyright(C) 2005-2009, Cadence Design Systems, Inc
// User: ykhuang Pid: 2887
// Design library name: EMG_TestBench
// Design cell name: TB_IA_V2
// Design view name: config
// Solver: Spectre

`include "disciplines.vams"
`include "userDisciplines.vams"
// HDL file - EMG_Model, IA_EMG_V2, verilogams.
// Library - EMG_TestBench, Cell - TB_IA_V2, View - schematic
// LAST TIME SAVED: Nov 17 23:34:59 2020
// NETLIST TIME: Nov 17 23:50:07 2020

`worklib EMG_TestBench
`view schematic

`timescale 1ns / 1ps
(* cds_ams_schematic *)

module TB_IA_V2 ( );
wire net7;
wire net8;
wire Voutp;
wire Voutn;
wire Vdda;
wire net9;
IA_EMG_V2 I0 (.Ibias( net9 ), .Vdda( Vdda ), .Voutn( Voutn ), .Voutp( Voutp ), .Vssa(cds_globals.\gnd! ), .Vsub(cds_globals.\gnd! ), .Vinn( net8 ), .Vinp( net7 ));
vsource #(.mag(1), .type("sine"), .ampl(0.005), .freq(100)) V2 (vsig, cds_globals.\gnd! );
vsource #(.dc(0), .type("dc")) V1 (Vin_CM, cds_globals.\gnd! );
vsource #(.dc(1.8), .type("dc")) V0 (Vdda, cds_globals.\gnd! );
vcvs #(.gain(1)) E2 (Vout, cds_globals.\gnd! , Voutp, Voutn);
vcvs #(.gain(0.5)) E1 (net8, Vin_CM, vsig, cds_globals.\gnd! );
vcvs #(.gain(-0.5)) E0 (net7, Vin_CM, vsig, cds_globals.\gnd! );
isource #(.dc(1e-05), .type("dc")) I2 (Vdda, net9);

endmodule
`noworklib
`noview
