// Design: Stimulator_TestBench/TB_Iref_imp
simulator lang=spectre
global 0
parameters vdd=3.3
include "/pkg/xfab/XKIT/xh018/cadence/v8_0/spectre/v8_0_1/lpmos/param.scs" section=3s
include "/pkg/xfab/XKIT/xh018/cadence/v8_0/spectre/v8_0_1/lpmos/bip.scs" section=tm
include "/pkg/xfab/XKIT/xh018/cadence/v8_0/spectre/v8_0_1/lpmos/cap.scs" section=ws
include "/pkg/xfab/XKIT/xh018/cadence/v8_0/spectre/v8_0_1/lpmos/dio.scs" section=tm
include "/pkg/xfab/XKIT/xh018/cadence/v8_0/spectre/v8_0_1/lpmos/mos.scs" section=wz
include "/pkg/xfab/XKIT/xh018/cadence/v8_0/spectre/v8_0_1/lpmos/photo.scs" section=tm
include "/pkg/xfab/XKIT/xh018/cadence/v8_0/spectre/v8_0_1/lpmos/res.scs" section=wp

// Stimulator_TestBench/TB_Iref_imp/schematic
R1 (net73 0) rpp1k1 l=150.295u w=2u m=1 par1=(1)
M43 (net81 net69 net06 0) ne3 w=2u l=1u m=(1)*(1)
M37 (Bias2 net06 net73 0) ne3 w=10u l=350.0n m=(1)*(1)
M28 (net06 net73 0 0) ne3 w=10u l=350.0n m=(1)*(1)
M53 (net69 net69 0 0) ne3 w=2u l=5u m=(1)*(1)
M50 (net80 Bias1 net81 net81) pe3 w=10u l=1u m=(1)*(1)
M48 (Bias1 Bias1 net81 net81) pe3 w=10u l=1u m=(1)*(1)
M54 (net69 net69 net81 net81) pe3 w=6u l=5u m=(1)*(1)
M51 (net06 Bias2 net80 net81) pe3 w=10u l=1u m=(1)*(1)
M49 (Bias2 Bias2 Bias1 net81) pe3 w=10u l=1u m=(1)*(1)
V0 (net81 0) vsource dc=vdd type=dc
simulatorOptions options reltol=100e-6 temp=-10 homotopy=all limit=delta compatible=spice2
dcOp dc
dc dc param=vdd start=0 stop=4
save M49:3
