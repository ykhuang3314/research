// Design: Stimulator_TestBench/TB_OneCH_Top
simulator lang=spectre binding=vlog
global 0 vdd3! vdde! vdd!
parameters Rload=1000
include "/pkg/xfab/XKIT/xh018/cadence/v8_0/spectre/v8_0_1/lpmos/param.scs" section=3s
include "/pkg/xfab/XKIT/xh018/cadence/v8_0/spectre/v8_0_1/lpmos/bip.scs" section=tm
include "/pkg/xfab/XKIT/xh018/cadence/v8_0/spectre/v8_0_1/lpmos/cap.scs" section=wp
include "/pkg/xfab/XKIT/xh018/cadence/v8_0/spectre/v8_0_1/lpmos/dio.scs" section=tm
include "/pkg/xfab/XKIT/xh018/cadence/v8_0/spectre/v8_0_1/lpmos/mos.scs" section=wo
include "/pkg/xfab/XKIT/xh018/cadence/v8_0/spectre/v8_0_1/lpmos/photo.scs"
include "/pkg/xfab/XKIT/xh018/cadence/v8_0/spectre/v8_0_1/lpmos/res.scs" section=tm

// Stimulator_IMP/Ext_Iref_ST/schematic
subckt Ext_Iref_ST
    R0 (Iext net9) rpp1k1 l=20.095u w=2u m=1 par1=(1)
    M3 (net8 net8 vss vss) ne3 w=20u l=1u m=(1)*(1)
    M2 (net9 net9 net8 vss) ne3 w=20u l=1u m=(1)*(1)
    M0 (Bias2 net9 net17 vss) ne3 w=20u l=1u m=(1)*(1)
    M1 (net17 net8 vss vss) ne3 w=20u l=1u m=(1)*(1)
    M48 (Bias1 Bias1 vdd3 vdd3) pe3 w=10u l=1u m=(1)*(1)
    M49 (Bias2 Bias2 Bias1 vdd3) pe3 w=10u l=1u m=(1)*(1)
ends Ext_Iref_ST

// D_CELLS_M3V/LSHVT18U3VX1/cmos_sch
subckt LSHVT18U3VX1
    M6 (Q net20 inh_power_vdd3 inh_power_vdd3) pe3 w=1.46u l=300n m=(1)*(1)
    M8 (net4 A inh_power_vdde inh_power_vdd3) pe3 w=1.48u l=300n m=(1)*(1)
    M9 (net20 A net024 inh_power_vdd3) pe3 w=420.0n l=300n m=(1)*(1)
    M0 (net10 net4 net023 inh_power_vdd3) pe3 w=420.0n l=300n m=(1)*(1)
    M2 (net023 net20 inh_power_vdd3 inh_power_vdd3) pe3 w=420.0n l=300n m=(1)*(1)
    M4 (net024 net10 inh_power_vdd3 inh_power_vdd3) pe3 w=420.0n l=300n m=(1)*(1)
    M3 (net20 A inh_ground_gnd inh_ground_gnd) ne3 w=1.31u l=350.0n m=(1)*(1)
    M5 (Q net20 inh_ground_gnd inh_ground_gnd) ne3 w=890.0n l=350.0n m=(1)*(1)
    M7 (net4 A inh_ground_gnd inh_ground_gnd) ne3 w=420.0n l=350.0n m=(1)*(1)
    M1 (net10 net4 inh_ground_gnd inh_ground_gnd) ne3 w=1.31u l=350.0n m=(1)*(1)
ends LSHVT18U3VX1

// GATES_3V/invrv3/schematic
subckt invrv3
parameters GT_PDW GT_PDL=350.00n sx=4.8e-07 lc=2.7e-07 GT_PUW GT_PUL=300.00n
    MN1 (out in inh_ground_gnd inh_ground_gnd) ne3 w=GT_PDW l=GT_PDL m=(1)*(1)
    MP1 (out in inh_power_vdd3 inh_power_vdd3) pe3 w=GT_PUW l=GT_PUL m=(1)*(1)
ends invrv3

// D_CELLS_3V/IN_3VX2/cmos_sch
subckt IN_3VX2
    invr_1 invrv3 GT_PDW=960.00n GT_PDL=350.00n sx=4.8e-07 lc=2.7e-07 GT_PUW=2.94u GT_PUL=300.00n
ends IN_3VX2

// GATES_HD/nand2/schematic
subckt nand2
parameters GT_PDW GT_PDL=180.00n sx=4.8e-07 lc=2.7e-07 GT_PUW GT_PUL=180.00n
    MN1 (out a net11 inh_ground_gnd) ne w=GT_PDW l=GT_PDL m=(1)*(1)
    MN2 (net11 b inh_ground_gnd inh_ground_gnd) ne w=GT_PDW l=GT_PDL m=(1)*(1)
    MP1 (out a inh_power_vdd inh_power_vdd) pe w=GT_PUW l=GT_PUL m=(1)*(1)
    MP2 (out b inh_power_vdd inh_power_vdd) pe w=GT_PUW l=GT_PUL m=(1)*(1)
ends nand2

// GATES_HD/invr/schematic
subckt invr
parameters GT_PDW GT_PDL=180.00n sx=4.8e-07 lc=2.7e-07 GT_PUW GT_PUL=180.00n
    ne (out in inh_ground_gnd inh_ground_gnd) ne w=GT_PDW l=GT_PDL m=(1)*(1)
    pe (out in inh_power_vdd inh_power_vdd) pe w=GT_PUW l=GT_PUL m=(1)*(1)
ends invr

// D_CELLS_HD/AND2HDX0/cmos_sch
subckt AND2HDX0
    nand2_1 nand2 GT_PDW=420.00n GT_PDL=180.00n sx=4.8e-07 lc=2.7e-07 GT_PUW=720.00n GT_PUL=180.00n
    invr_1 invr GT_PDW=420.00n GT_PDL=180.00n sx=4.8e-07 lc=2.7e-07 GT_PUW=720.00n GT_PUL=180.00n
ends AND2HDX0

// Stimulator_IMP/Idac_5bit_ST/schematic
subckt Idac_5bit_ST
    M41 (net31 Bias1 vdd3 vdd3) pe3 w=10u l=1u m=(1)*(16)
    M38 (net33 Bias1 vdd3 vdd3) pe3 w=10u l=1u m=(1)*(8)
    M35 (net35 Bias1 vdd3 vdd3) pe3 w=10u l=1u m=(1)*(4)
    M32 (net37 Bias1 vdd3 vdd3) pe3 w=10u l=1u m=(1)*(2)
    M22 (net39 Bias1 vdd3 vdd3) pe3 w=10u l=1u m=(1)*(1)
    M42 (net30 Bias2 net31 vdd3) pe3 w=10u l=1u m=(1)*(16)
    M39 (net32 Bias2 net33 vdd3) pe3 w=10u l=1u m=(1)*(8)
    M36 (net34 Bias2 net35 vdd3) pe3 w=10u l=1u m=(1)*(4)
    M33 (net36 Bias2 net37 vdd3) pe3 w=10u l=1u m=(1)*(2)
    M29 (net38 Bias2 net39 vdd3) pe3 w=10u l=1u m=(1)*(1)
    M44 (Idac D1_3v net36 vdd3) pe3 w=10u l=300n m=(1)*(1)
    M45 (Idac D2_3v net34 vdd3) pe3 w=10u l=300n m=(1)*(1)
    M46 (Idac D3_3v net32 vdd3) pe3 w=10u l=300n m=(1)*(1)
    M47 (Idac D4_3v net30 vdd3) pe3 w=10u l=300n m=(1)*(1)
    M31 (Idac D0_3v net38 vdd3) pe3 w=10u l=300n m=(1)*(1)
    I16 LSHVT18U3VX1
    I30 LSHVT18U3VX1
    I14 LSHVT18U3VX1
    I12 LSHVT18U3VX1
    I29 LSHVT18U3VX1
    I31 IN_3VX2
    I15 IN_3VX2
    I13 IN_3VX2
    I11 IN_3VX2
    I10 IN_3VX2
    I45 AND2HDX0
    I46 AND2HDX0
    I47 AND2HDX0
    I48 AND2HDX0
    I49 AND2HDX0
ends Idac_5bit_ST

// D_CELLS_M3V/LSHVT18U3VX2/cmos_sch
subckt LSHVT18U3VX2
    M6 (Q net20 inh_power_vdd3 inh_power_vdd3) pe3 w=2.82u l=300n m=(1)*(1)
    M8 (net4 A inh_power_vdde inh_power_vdd3) pe3 w=1.47u l=300n m=(1)*(1)
    M9 (net20 A net024 inh_power_vdd3) pe3 w=420.0n l=300n m=(1)*(1)
    M0 (net10 net4 net023 inh_power_vdd3) pe3 w=420.0n l=300n m=(1)*(1)
    M2 (net023 net20 inh_power_vdd3 inh_power_vdd3) pe3 w=420.0n l=300n m=(1)*(1)
    M4 (net024 net10 inh_power_vdd3 inh_power_vdd3) pe3 w=420.0n l=300n m=(1)*(1)
    M3 (net20 A inh_ground_gnd inh_ground_gnd) ne3 w=1.31u l=350.0n m=(1)*(1)
    M5 (Q net20 inh_ground_gnd inh_ground_gnd) ne3 w=1.78u l=350.0n m=(1)*(1)
    M7 (net4 A inh_ground_gnd inh_ground_gnd) ne3 w=420.0n l=350.0n m=(1)*(1)
    M1 (net10 net4 inh_ground_gnd inh_ground_gnd) ne3 w=1.31u l=350.0n m=(1)*(1)
ends LSHVT18U3VX2

// Stimulator_IMP/CurrentMirror_ST/schematic
subckt CurrentMirror_ST
    C5 (vddh net014) csft5a area=6.3936e-11 perimeter=33.72u m=15 par1=(15)
    C1 (net014 vss) csft5a area=6.3936e-11 perimeter=33.72u m=45 par1=(45)
    M26 (Iref Iref vss vss) ne3 w=40u l=2u m=(1)*(1)
    M13 (net11 Iref vss vss) ne3 w=40u l=2u m=(1)*(10)
    M17 (net11 net014 vss vss) nedia_bjt w=10u l=1.25u m=(1)*(1) par1=((1)*(1)) extlay=0 xf_subext=0
    M15 (net014 vdd3 vss vss) nedia_bjt w=10u l=1.25u m=(1)*(1) par1=((1)*(1)) extlay=0 xf_subext=0
    M14 (net016 net016 net19 vss) nedia_bjt w=30u l=1.25u m=(1)*(1) par1=((1)*(1)) extlay=0 xf_subext=0
    M8 (net17 net17 VB vss) nedia_bjt w=60u l=1.25u m=(1)*(1) par1=((1)*(1)) extlay=0 xf_subext=0
    M16 (Bias2 en_3v net11 vss) nedia_bjt w=60u l=1.25u m=(1)*(5) par1=((1)*(5)) extlay=0 xf_subext=0
    M5 (net19 VB net26 vss) nedia_bjt w=60u l=1.25u m=(1)*(1) par1=((1)*(1)) extlay=0 xf_subext=0
    M0 (Ist VB net25 vss) nedia_bjt w=60u l=1.25u m=(1)*(10) par1=((1)*(10)) extlay=0 xf_subext=0
    M7 (VB net17 net16 vss) nedia_bjt w=20u l=1.25u m=(1)*(1) par1=((1)*(1)) extlay=0 xf_subext=0
    M6 (net16 net16 vss vss) nedia_bjt w=60u l=1.25u m=(1)*(1) par1=((1)*(1)) extlay=0 xf_subext=0
    M4 (net26 net19 vss vss) nedia_bjt w=60u l=1.25u m=(1)*(1) par1=((1)*(1)) extlay=0 xf_subext=0
    M3 (net25 net19 vss vss) nedia_bjt w=60u l=1.25u m=(1)*(10) par1=((1)*(10)) extlay=0 xf_subext=0
    I17 LSHVT18U3VX2
    M11 (net23 net013 vddh vss) ped_bjt w=30u l=940.0n m=(1)*(1) par1=((1)*(1)) extlay=0 xf_subext=0
    M1 (net24 net013 vddh vss) ped_bjt w=30u l=940.0n m=(1)*(1) par1=((1)*(1)) extlay=0 xf_subext=0
    M2 (net013 net013 vddh vss) ped_bjt w=30u l=940.0n m=(1)*(1) par1=((1)*(1)) extlay=0 xf_subext=0
    M12 (net016 Bias2 net23 vss) ped_bjt w=30u l=940.0n m=(1)*(1) par1=((1)*(1)) extlay=0 xf_subext=0
    M10 (net17 Bias2 net24 vss) ped_bjt w=30u l=940.0n m=(1)*(1) par1=((1)*(1)) extlay=0 xf_subext=0
    M9 (Bias2 Bias2 net013 vss) ped_bjt w=30u l=940.0n m=(1)*(1) par1=((1)*(1)) extlay=0 xf_subext=0
    R1 (vdd3 vss) rpp1k1 l=202.905u w=2u m=1 par1=(1)
    R0 (en_3v vss) rpp1k1 l=202.905u w=2u m=1 par1=(1)
ends CurrentMirror_ST

// Stimulator_IMP/CurrentSource_All_ST/schematic
subckt CurrentSource_All_ST
    I0 Ext_Iref_ST
    I1 Idac_5bit_ST
    I2 CurrentMirror_ST
ends CurrentSource_All_ST

// Stimulator_IMP/LS_HighSide_V3_ST/schematic
subckt LS_HighSide_V3_ST
    M13 (net10 inn3v 0 0) nedia_bjt w=10u l=1.25u m=(1)*(5) par1=((1)*(5)) extlay=0 xf_subext=0
    R0 (vddh out) rpp1k1 l=304.47u w=2u m=1 par1=(1)
    R1 (out net10) rpp1k1 l=507.595u w=2u m=1 par1=(1)
    I10 LSHVT18U3VX1
ends LS_HighSide_V3_ST

// Stimulator_IMP/LS_LowSide_V2_ST/schematic
subckt LS_LowSide_V2_ST
    M0 (net12 in_3V 0 0) nedia_bjt w=30u l=1.25u m=(1)*(1) par1=((1)*(1)) extlay=0 xf_subext=0
    R2 (net9 net12) rpp1k1 l=507.595u w=2u m=1 par1=(1)
    R0 (out 0) rpp1k1 l=304.47u w=2u m=1 par1=(1)
    R1 (vddh net9) rpp1k1 l=304.47u w=2u m=1 par1=(1)
    R3 (net11 out) rpp1k1 l=507.595u w=2u m=1 par1=(1)
    M1 (net11 net9 vddh 0) ped_bjt w=30u l=940.0n m=(1)*(1) par1=((1)*(1)) extlay=0 xf_subext=0
    I0 LSHVT18U3VX1
ends LS_LowSide_V2_ST

// Stimulator_IMP/HalfBridge_ST/schematic
subckt HalfBridge_ST
    I8 LS_HighSide_V3_ST
    M34 (OUT net08 Ist 0) nedia_bjt w=100.0000u l=1.25u m=(1)*(6) par1=((1)*(6)) extlay=0 xf_subext=0
    M66 (OUT net07 vddh 0) ped_bjt w=100.0000u l=940.0n m=(1)*(6) par1=((1)*(6)) extlay=0 xf_subext=0
    I9 LS_LowSide_V2_ST
ends HalfBridge_ST

// Stimulator_IMP/SingleChannel_ST/schematic
subckt SingleChannel_ST
    I0 CurrentSource_All_ST
    I2 HalfBridge_ST
    I1 HalfBridge_ST
ends SingleChannel_ST

// Stimulator_TestBench/TB_OneCH_Top/schematic
I0 SingleChannel_ST
I1 (vdd3! net6) isource dc=10u type=dc
R0 (vout1 vout2) resistor r=Rload
V3 (vdd! 0) vsource dc=1.8 type=dc
V2 (vddh 0) vsource dc=40 type=dc
V0 (vdde! 0) vsource dc=1.8 type=dc
V1 (vdd3! 0) vsource dc=3.3 type=dc
simulatorOptions options temp=27 reltol=100e-6 homotopy=all limit=delta resolve_duplicate_master=subckt duplicate_subckt=warning portmismatch_severity=warning
