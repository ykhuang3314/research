// This is the Cadence AMS Designer(R) analog simulation control file.
// It specifies the options and analyses for the Spectre analog solver.

simulator lang=spectre

global 0 vdd3! vdde! vdd!

simulatorOptions options temp=27 tnom=27 scale=1.0 scalem=1.0 \
reltol=100e-6 vabstol=1e-6 iabstol=1e-12 homotopy=all limit=delta \
gmin=1e-12 rforce=1 maxnotes=5 maxwarns=5 digits=5 pivrel=1e-3 \
checklimitdest=psf

tran tran stop=2.5m errpreset=conservative write="spectre.ic" \
writefinal="spectre.fc" annotate=status maxiters=5

finalTimeOP info what=oppoint where=rawfile

modelParameter info what=models where=rawfile
element info what=inst where=rawfile
outputParameter info what=output where=rawfile

wave_out options rawfmt=sst2
save TB_OneCH_Top.I0.I0.I2.M0:vds TB_OneCH_Top.I0.I0.I2.M0:vdsat \
TB_OneCH_Top.I0.I0.I2.M3:vds TB_OneCH_Top.I0.I0.I2.M3:vdsat
