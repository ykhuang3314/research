// -----------------------------------------------------------------------------
// (c) Copyright 2010 Cadence Design Systems, Inc. All rights reserved worldwide.
// -----------------------------------------------------------------------------

// Binding AMSD Control Block for config Stimulator_TestBench.TB_Stimulus_Driver:config
// Created On: Jan 13 15:26:50 2021
// NOTE      : DO NOT change this system generated file.

amsd {
	config designtop="Stimulator_TestBench.TB_Stimulus_Driver:schematic"

	config cell="Current_Source" lib="Stimulator_Model" view="verilogams"
	config cell="Stimulus_Driver" lib="Stimulator_Model" view="verilogams"
	config cell="isource" view="analogtext"
	config cell="vsource" view="analogtext"
	config cell="resistor" view="analogtext"
	config cell="Counter" lib="Digital_Lib" view="functional"

 }
