// AMS netlist generated by the AMS Unified netlister
// IC subversion:  IC6.1.8-64b.500.7
// Xcelium version: 18.03-s018
// Copyright(C) 2005-2009, Cadence Design Systems, Inc
// User: ykhuang Pid: 5922
// Design library name: Stimulator_TestBench
// Design cell name: TB_Stimulus_Driver
// Design view name: config
// Solver: Spectre

`include "disciplines.vams"
`include "userDisciplines.vams"
// HDL file - Digital_Lib, Counter, functional.
// HDL file - Stimulator_Model, Current_Source, verilogams.
// HDL file - Stimulator_Model, Stimulus_Driver, verilogams.
// Library - Stimulator_TestBench, Cell - TB_Stimulus_Driver, View - schematic
// LAST TIME SAVED: Jan 13 15:24:55 2021
// NETLIST TIME: Jan 13 15:26:48 2021

`worklib Stimulator_TestBench
`view schematic

`timescale 1ns / 1ps
(* cds_ams_schematic *)

module TB_Stimulus_Driver ( );
wire [4:0] Mag;
wire ANO;
wire CAT;
wire net5;
wire Vdda;
wire VddH;
wire Ibais_right;
wire net6;
wire Ibias_left;
wire Vssa;
wire net05;
wire net04;
wire CLK;
Stimulus_Driver I9 (.Ibias( Ibais_right ), .VddH( VddH ), .Vdda( Vdda ), .Vssa(cds_globals.\gnd! ), .Out( net5 ), .ANO( CAT ), .CAT( ANO ));
Stimulus_Driver I7 (.Ibias( Ibias_left ), .VddH( VddH ), .Vdda( Vdda ), .Vssa(cds_globals.\gnd! ), .Out( net6 ), .ANO( ANO ), .CAT( CAT ));
Current_Source I14 (.Ibias( net05 ), .Vdda( Vdda ), .Vssa( Vssa ), .Ioutn( Ibais_right ), .Ioutp( Vdda ), .Mag( Mag ));
Current_Source I10 (.Ibias( net04 ), .Vdda( Vdda ), .Vssa( Vssa ), .Ioutn( Ibias_left ), .Ioutp( Vdda ), .Mag( Mag ));
Counter I12 (.out( Mag ), .CLK( CLK ), .EN( Vdda ), .RESET( Vssa ));
resistor #(.r(1000)) R0 (net6, net5);
vsource #(.type("pulse"), .val0(0), .val1(1.8), .period(0.00022), .delay(0.00022), .rise(1e-12), .fall(1e-12), .width(0.00011)) V4 (CLK, cds_globals.\gnd! );
vsource #(.type("pulse"), .val0(0), .val1(1.8), .period(0.00022), .delay(0.00012), .rise(1e-12), .fall(1e-12), .width(0.0001)) V3 (CAT, cds_globals.\gnd! );
vsource #(.type("pulse"), .val0(0), .val1(1.8), .period(0.00022), .delay(1e-05), .rise(1e-12), .fall(1e-12), .width(0.0001)) V0 (ANO, cds_globals.\gnd! );
vsource #(.dc(1.8), .type("dc")) V2 (Vdda, cds_globals.\gnd! );
vsource #(.dc(30), .type("dc")) V1 (VddH, cds_globals.\gnd! );
isource #(.dc(1e-05), .type("dc")) I13 (Vdda, net05);
isource #(.dc(1e-05), .type("dc")) I11 (Vdda, net04);

endmodule
`noworklib
`noview
