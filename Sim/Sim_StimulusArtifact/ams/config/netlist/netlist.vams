// AMS netlist generated by the AMS Unified netlister
// IC subversion:  IC6.1.8-64b.500.7
// Xcelium version: 18.03-s018
// Copyright(C) 2005-2009, Cadence Design Systems, Inc
// User: ykhuang Pid: 15215
// Design library name: EMG_NMES_TestBench
// Design cell name: Sim_StimulusArtifact
// Design view name: config
// Solver: Spectre

`include "disciplines.vams"
`include "userDisciplines.vams"
// HDL file - EMG_Model, IA_EMG_Ideal, verilogams.
// HDL file - EMG_Model, PGA_EMG, verilogams.
// HDL file - EMG_Model, BPF_EMG, verilogams.
// HDL file - Stimulator_Model, H_Bridge, verilogams.
// HDL file - Stimulator_Model, Current_Mirror, verilogams.
// HDL file - Stimulator_Model, Current_Source, verilogams.
// Library - EMG_Model, Cell - AFE_EMG, View - schematic
// LAST TIME SAVED: Feb  9 12:37:09 2021
// NETLIST TIME: Feb 10 18:47:42 2021

`worklib EMG_Model
`view schematic

`timescale 1ns / 1ps
(* cds_ams_schematic *)

module AFE_EMG (Vout, Ibias, Vdda, Vddd, Vssa, Vssd, Vsub, Gain_Sel, Vinn, Vinp);
output  Vout;
input  Vinn, Vinp;
inout  Ibias, Vdda, Vddd, Vssa, Vssd, Vsub;
input [2:0] Gain_Sel;
wire Voutp_IA;
wire Voutn_IA;
wire Voutp_BPF;
wire Voutn_BPF;
BPF_EMG I1 (.Ibias( Ibias ), .Vdda( Vdda ), .Vssa( Vssa ), .Vsub( Vsub ), .Voutn( Voutn_BPF ), .Voutp( Voutp_BPF ), .Vinn( Voutn_IA ), .Vinp( Voutp_IA ));
PGA_EMG I2 (.Vddd( Vddd ), .Vssd( Vssd ), .Ibias( Ibias ), .Vdda( Vdda ), .Vssa( Vssa ), .Vsub( Vsub ), .Vout( Vout ), .Gain_Sel( Gain_Sel ), .Vinn( Voutn_BPF ), .Vinp( Voutp_BPF ));
IA_EMG_Ideal I0 (.Ibias( Ibias ), .Vdda( Vdda ), .Vssa( Vssa ), .Vsub( Vsub ), .Voutn( Voutn_IA ), .Voutp( Voutp_IA ), .Vinn( Vinn ), .Vinp( Vinp ));

endmodule
// Library - EMG_NMES_TestBench, Cell - Sim_StimulusArtifact, View - schematic
// LAST TIME SAVED: Feb 10 18:47:32 2021
// NETLIST TIME: Feb 10 18:47:42 2021

`worklib EMG_NMES_TestBench
`view schematic

`timescale 1ns / 1ps
(* cds_ams_schematic *)

module Sim_StimulusArtifact ( );
wire [2:0] Gain_Sel;
wire [4:0] Mag;
wire net3;
wire CAT;
wire ANO;
wire net2;
wire net1;
wire Vssa;
wire Vdda;
wire VddH;
wire Vddd;
wire Vssd;
wire Vinp;
wire Vout;
wire Vsub;
wire net4;
Stimulator_Single_CH I0 (.Vssd( Vssd ), .Vddd( Vddd ), .VddH( VddH ), .Vdda( Vdda ), .Vssa( Vssa ), .Iano( net1 ), .Icat( net2 ), .ANO( ANO ), .CAT( CAT ), .DIS(cds_globals.\gnd! ), .Ibias( net3 ), .Mag( Mag[4:0] ));
AFE_EMG I1 (.Vddd( Vddd ), .Vssd( Vssd ), .Ibias( net4 ), .Vdda( Vdda ), .Vssa( Vssa ), .Vsub( Vsub ), .Vout( Vout ), .Gain_Sel( Gain_Sel[2:0] ), .Vinn(cds_globals.\gnd! ), .Vinp( Vinp ));
resistor #(.r(1000000000)) R10 (Vinp, cds_globals.\gnd! );
resistor #(.r(1000)) R6 (Vinp, net09);
resistor #(.r(500)) R9 (net017, net09);
resistor #(.r(1000)) R5 (net2, net016);
resistor #(.r(500)) R4 (net017, net016);
resistor #(.r(1000)) R3 (net1, net017);
isource #(.dc(1e-05), .type("dc")) I5 (Vdda, net4);
isource #(.dc(1e-05), .type("dc")) I3 (Vdda, net3);
vsource #(.dc(0), .type("dc")) V19 (Vssd, cds_globals.\gnd! );
vsource #(.dc(1.8), .type("dc")) V18 (Vddd, cds_globals.\gnd! );
vsource #(.dc(0), .type("dc")) V17 (Gain_Sel[0], cds_globals.\gnd! );
vsource #(.dc(0), .type("dc")) V16 (Gain_Sel[1], cds_globals.\gnd! );
vsource #(.dc(1.8), .type("dc")) V15 (Gain_Sel[2], cds_globals.\gnd! );
vsource #(.dc(1.8), .type("dc")) V12 (Mag[0], cds_globals.\gnd! );
vsource #(.dc(0), .type("dc")) V11 (Mag[1], cds_globals.\gnd! );
vsource #(.dc(0), .type("dc")) V10 (Mag[2], cds_globals.\gnd! );
vsource #(.dc(1.8), .type("dc")) V9 (Mag[3], cds_globals.\gnd! );
vsource #(.dc(0), .type("dc")) V8 (Mag[4], cds_globals.\gnd! );
vsource #(.dc(0), .type("dc")) V6 (Vssa, cds_globals.\gnd! );
vsource #(.dc(1.8), .type("dc")) V2 (Vdda, cds_globals.\gnd! );
vsource #(.dc(30), .type("dc")) V1 (VddH, cds_globals.\gnd! );
vsource #(.dc(0), .type("dc")) V4 (Vsub, cds_globals.\gnd! );
vsource #(.type("pulse"), .val0(1.8), .val1(0), .period(0.00045), .delay(0.00042), .rise(1e-12), .fall(1e-12), .width(3e-05)) V14 (Vctrl_inv, cds_globals.\gnd! );
vsource #(.type("pulse"), .val0(0), .val1(1.8), .period(0.00045), .delay(0.00042), .rise(1e-12), .fall(1e-12), .width(3e-05)) V13 (Vctrl, cds_globals.\gnd! );
vsource #(.type("pulse"), .val0(0), .val1(1.8), .period(0.00045), .delay(1e-05), .rise(1e-12), .fall(1e-12), .width(0.0002)) V0 (ANO, cds_globals.\gnd! );
vsource #(.type("pulse"), .val0(0), .val1(1.8), .period(0.00045), .delay(0.00022), .rise(1e-12), .fall(1e-12), .width(0.0002)) V3 (CAT, cds_globals.\gnd! );
vsource #(.type("pulse"), .val0(0), .val1(1.8), .period(0.00045), .delay(0.00042), .rise(1e-12), .fall(1e-12), .width(1e-05)) V5 (DIS, cds_globals.\gnd! );
relay #(.vt1(0), .vt2(1.5), .ropen(1e+12), .rclosed(1)) W3 (net019, net018, Vctrl, cds_globals.\gnd! );
capacitor #(.c(1e-09)) C1 (Vinp, net09);
capacitor #(.c(1e-09)) C3 (net2, net016);
capacitor #(.c(1e-09)) C2 (net1, net017);

endmodule
// Library - Stimulator_Model, Cell - Stimulator_Single_CH, View - schematic
// LAST TIME SAVED: Feb  9 12:10:15 2021
// NETLIST TIME: Feb 10 18:47:42 2021

`worklib Stimulator_Model
`view schematic

`timescale 1ns / 1ps
(* cds_ams_schematic *)

module Stimulator_Single_CH (Iano, Icat, VddH, Vdda, Vddd, Vssa, Vssd, ANO, CAT, DIS, Ibias, Mag);
output  Iano, Icat;
input  ANO, CAT, DIS, Ibias;
inout  VddH, Vdda, Vddd, Vssa, Vssd;
input [4:0] Mag;
wire net11;
wire net12;
Current_Source I10 (.Vssd( Vssd ), .Vddd( Vddd ), .Ibias( Ibias ), .Vdda( Vdda ), .Vssa( Vssa ), .Ioutn( net11 ), .Ioutp( Vdda ), .Mag( Mag ));
Current_Mirror I2 (.Iref( net11 ), .Iout( net12 ), .Vdda( Vdda ), .Vssa( Vssa ));
H_Bridge I3 (.Vssd( Vssd ), .Vddd( Vddd ), .Ist( net12 ), .VddH( VddH ), .Vdda( Vdda ), .Vssa( Vssa ), .Iano( Iano ), .Icat( Icat ), .ANO( ANO ), .CAT( CAT ), .DIS( DIS ));

endmodule
`noworklib
`noview
