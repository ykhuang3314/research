// AMS netlist generated by the AMS Unified netlister
// IC subversion:  IC6.1.8-64b.500.7
// Xcelium version: 18.03-s018
// Copyright(C) 2005-2009, Cadence Design Systems, Inc
// User: ykhuang Pid: 8366
// Design library name: EMG_NMES_TestBench
// Design cell name: Sim_StimulusArtifact
// Design view name: config
// Solver: Spectre

`include "disciplines.vams"
`include "userDisciplines.vams"
// HDL file - EMG_Model, PGA_EMG, verilogams.
// HDL file - EMG_Model, IA_EMG, verilogams.
// HDL file - EMG_Model, BPF_EMG, verilogams.
// HDL file - Stimulator_Model, H_Bridge, verilogams.
// HDL file - Stimulator_Model, Current_Mirror, verilogams.
// HDL file - Stimulator_Model, Current_Source, verilogams.
// Library - EMG_Model, Cell - AFE_EMG, View - schematic
// LAST TIME SAVED: Jan 18 10:48:22 2021
// NETLIST TIME: Feb  9 11:20:17 2021

`worklib EMG_Model
`view schematic

`timescale 1ns / 1ps
(* cds_ams_schematic *)

module AFE_EMG (Vout, Ibias, Vdda, Vssa, Vsub, Gain_Sel, Vinn, Vinp);
output  Vout;
input  Vinn, Vinp;
inout  Ibias, Vdda, Vssa, Vsub;
input [2:0] Gain_Sel;
wire Voutp_IA;
wire Voutn_IA;
wire Voutp_BPF;
wire Voutn_BPF;
BPF_EMG I1 (.Ibias( Ibias ), .Vdda( Vdda ), .Vssa( Vssa ), .Vsub( Vsub ), .Voutn( Voutn_BPF ), .Voutp( Voutp_BPF ), .Vinn( Voutn_IA ), .Vinp( Voutp_IA ));
IA_EMG #(.ip3( - (12.8))) I0 (.Ibias( Ibias ), .Vdda( Vdda ), .Vssa( Vssa ), .Vsub( Vsub ), .Voutn( Voutn_IA ), .Voutp( Voutp_IA ), .Vinn( Vinn ), .Vinp( Vinp ));
PGA_EMG I2 (.Ibias( Ibias ), .Vdda( Vdda ), .Vssa( Vssa ), .Vsub( Vsub ), .Vout( Vout ), .Gain_Sel( Gain_Sel ), .Vinn( Voutn_BPF ), .Vinp( Voutp_BPF ));

endmodule
// Library - EMG_NMES_TestBench, Cell - Sim_StimulusArtifact, View - schematic
// LAST TIME SAVED: Feb  9 11:20:05 2021
// NETLIST TIME: Feb  9 11:20:17 2021

`worklib EMG_NMES_TestBench
`view schematic

`timescale 1ns / 1ps
(* cds_ams_schematic *)

module Sim_StimulusArtifact ( );
wire [2:0] Gain_Sel;
wire [4:0] Mag;
wire net3;
wire DIS;
wire CAT;
wire ANO;
wire net2;
wire net1;
wire Vssa;
wire Vdda;
wire VddH;
wire net08;
wire Vout;
wire Vsub;
wire net4;
Stimulator_Single_CH I0 (.VddH( VddH ), .Vdda( Vdda ), .Vssa( Vssa ), .Iano( net1 ), .Icat( net2 ), .ANO( ANO ), .CAT( CAT ), .DIS( DIS ), .Ibias( net3 ), .Mag( Mag[4:0] ));
AFE_EMG I1 (.Ibias( net4 ), .Vdda( Vdda ), .Vssa( Vssa ), .Vsub( Vsub ), .Vout( Vout ), .Gain_Sel( Gain_Sel[2:0] ), .Vinn(cds_globals.\gnd! ), .Vinp( net08 ));
resistor #(.r(1000000)) R6 (net08, net07);
resistor #(.r(500)) R2 (net016, net07);
resistor #(.r(500)) R1 (net017, net07);
resistor #(.r(1000000)) R5 (net2, net016);
resistor #(.r(1000)) R4 (net017, net016);
resistor #(.r(1000000)) R3 (net1, net017);
isource #(.dc(1e-05), .type("dc")) I5 (Vdda, net4);
isource #(.dc(1e-05), .type("dc")) I3 (Vdda, net3);
vsource #(.dc(0), .type("dc")) V17 (Gain_Sel[0], cds_globals.\gnd! );
vsource #(.dc(0), .type("dc")) V16 (Gain_Sel[1], cds_globals.\gnd! );
vsource #(.dc(1.8), .type("dc")) V15 (Gain_Sel[2], cds_globals.\gnd! );
vsource #(.dc(1.8), .type("dc")) V12 (Mag[0], cds_globals.\gnd! );
vsource #(.dc(0), .type("dc")) V11 (Mag[1], cds_globals.\gnd! );
vsource #(.dc(0), .type("dc")) V10 (Mag[2], cds_globals.\gnd! );
vsource #(.dc(1.8), .type("dc")) V9 (Mag[3], cds_globals.\gnd! );
vsource #(.dc(0), .type("dc")) V8 (Mag[4], cds_globals.\gnd! );
vsource #(.dc(0), .type("dc")) V4 (Vsub, cds_globals.\gnd! );
vsource #(.dc(0), .type("dc")) V6 (Vssa, cds_globals.\gnd! );
vsource #(.dc(1.8), .type("dc")) V2 (Vdda, cds_globals.\gnd! );
vsource #(.dc(30), .type("dc")) V1 (VddH, cds_globals.\gnd! );
vsource #(.dc(0), .type("dc")) V5 (DIS, cds_globals.\gnd! );
vsource #(.type("pulse"), .val0(0), .val1(1.8), .period(0.00022), .delay(1e-05), .rise(1e-12), .fall(1e-12), .width(0.0001)) V0 (ANO, cds_globals.\gnd! );
vsource #(.type("pulse"), .val0(0), .val1(1.8), .period(0.00022), .delay(0.00012), .rise(1e-12), .fall(1e-12), .width(0.0001)) V3 (CAT, cds_globals.\gnd! );
vsource #(.type("sine"), .ampl(0.001), .freq(300)) V7 (Vinp, cds_globals.\gnd! );
capacitor #(.c(1e-09)) C1 (net08, net07);
capacitor #(.c(1e-09)) C3 (net2, net016);
capacitor #(.c(1e-09)) C2 (net1, net017);

endmodule
// Library - Stimulator_Model, Cell - Stimulator_Single_CH, View - schematic
// LAST TIME SAVED: Feb  8 15:30:20 2021
// NETLIST TIME: Feb  9 11:20:17 2021

`worklib Stimulator_Model
`view schematic

`timescale 1ns / 1ps
(* cds_ams_schematic *)

module Stimulator_Single_CH (Iano, Icat, VddH, Vdda, Vssa, ANO, CAT, DIS, Ibias, Mag);
output  Iano, Icat;
input  ANO, CAT, DIS, Ibias;
inout  VddH, Vdda, Vssa;
input [4:0] Mag;
wire net11;
wire net12;
Current_Source I10 (.Ibias( Ibias ), .Vdda( Vdda ), .Vssa( Vssa ), .Ioutn( net11 ), .Ioutp( Vdda ), .Mag( Mag ));
Current_Mirror I2 (.Iref( net11 ), .Iout( net12 ), .Vdda( Vdda ), .Vssa( Vssa ));
H_Bridge I3 (.Ist( net12 ), .VddH( VddH ), .Vdda( Vdda ), .Vssa( Vssa ), .Iano( Iano ), .Icat( Icat ), .ANO( ANO ), .CAT( CAT ), .DIS( DIS ));

endmodule
`noworklib
`noview
