// AMS netlist generated by the AMS Unified netlister
// IC subversion:  IC6.1.8-64b.500.7
// Xcelium version: 18.03-s018
// Copyright(C) 2005-2009, Cadence Design Systems, Inc
// User: ykhuang Pid: 15442
// Design library name: EMG_NMES_TestBench
// Design cell name: Sim_StimulusArtifact
// Design view name: config
// Solver: Spectre

`include "disciplines.vams"
`include "userDisciplines.vams"
// HDL file - Stimulator_IMP, Digital_Stimulus_V2_ST, functional.
// HDL file - EMG_Model, IA_EMG_Ideal, verilogams.
// HDL file - EMG_Model, PGA_EMG, verilogams.
// HDL file - EMG_Model, BPF_EMG, verilogams.
// HDL file - Stimulator_IMP, Decoder3_8, functional.
// Library - Stimulator_IMP, Cell - Ext_Iref_ST, View - schematic
// LAST TIME SAVED: May 11 12:03:33 2021
// NETLIST TIME: May 13 15:52:39 2021

`worklib Stimulator_IMP
`view schematic

`timescale 1ns / 1ps
(* cds_ams_schematic *)

module Ext_Iref_ST (Iext, Iref, vss);
inout  Iext, Iref, vss;
rpp1k1 #(.l(2.0095e-05), .w(2e-06), .m(1), .par1(1))
(* integer passed_mfactor = "m"; *)
 R0 (Iext, VG2);
ne3 #(.w(8e-06), .l(2e-06), .as(3.84e-12), .ad(3.84e-12), .ps(1.696e-05), .pd(1.696e-05), .nrs(0.03375), .nrd(0.03375), .m((5)*(1)), .par1((5)*(1)), .xf_subext(0))
(* integer passed_mfactor = "m"; *)
 M2 (VG1, VG1, vss, vss);
ne3 #(.w(8e-06), .l(2e-06), .as(3.84e-12), .ad(3.84e-12), .ps(1.696e-05), .pd(1.696e-05), .nrs(0.03375), .nrd(0.03375), .m((5)*(1)), .par1((5)*(1)), .xf_subext(0))
(* integer passed_mfactor = "m"; *)
 M0 (VG2, VG2, VG1, vss);
ne3 #(.w(8e-06), .l(2e-06), .as(3.84e-12), .ad(3.84e-12), .ps(1.696e-05), .pd(1.696e-05), .nrs(0.03375), .nrd(0.03375), .m((5)*(1)), .par1((5)*(1)), .xf_subext(0))
(* integer passed_mfactor = "m"; *)
 M3 (VD_M1, VG1, vss, vss);
ne3 #(.w(8e-06), .l(2e-06), .as(3.84e-12), .ad(3.84e-12), .ps(1.696e-05), .pd(1.696e-05), .nrs(0.03375), .nrd(0.03375), .m((5)*(1)), .par1((5)*(1)), .xf_subext(0))
(* integer passed_mfactor = "m"; *)
 M1 (Iref, VG2, VD_M1, vss);
ne3 #(.w(8e-06), .l(2e-06), .as(3.84e-12), .ad(3.84e-12), .ps(1.696e-05), .pd(1.696e-05), .nrs(0.03375), .nrd(0.03375), .m((4)*(1)), .par1((4)*(1)), .xf_subext(0))
(* integer passed_mfactor = "m"; *)
 M14 (vss, vss, vss, vss);

endmodule
// Library - Stimulator_IMP, Cell - CurrentSource_All_ST, View - schematic
// LAST TIME SAVED: May  4 13:56:45 2021
// NETLIST TIME: May 13 15:52:39 2021

`worklib Stimulator_IMP
`view schematic

`timescale 1ns / 1ps
(* cds_ams_schematic *)

module CurrentSource_All_ST (Iext, Ist, .\gnd! (cdsNet1), .\vdd3! (cdsNet0), vddh, Enable_ST, Mag0_ST, Mag1_ST, Mag2_ST, Mag3_ST, Mag4_ST);
input  Enable_ST, Mag0_ST, Mag1_ST, Mag2_ST, Mag3_ST, Mag4_ST;
inout  Iext, Ist, cdsNet1, cdsNet0, vddh;
wire Iref;
wire net05;
wire net07;
wire net09;
wire net011;
wire net013;
wire net9;
wire D0_3v;
wire D2_3v;
wire D1_3v;
wire D3_3v;
wire D4_3v;
wire net06;
wire net08;
wire net010;
wire net012;
wire net014;
cds_alias #(1) cds_alias_inst5 ( cdsNet1 , cds_globals.\gnd! );
cds_alias #(1) cds_alias_inst6 ( cdsNet0 , cds_globals.\vdd3! );
Ext_Iref_ST I0 (.Iref( Iref ), .Iext( Iext ), .vss(cds_globals.\gnd! ));
AND2HDX0 I45 (.Q( net05 ), .B( Mag0_ST ), .A( Enable_ST ));
AND2HDX0 I46 (.Q( net07 ), .B( Mag1_ST ), .A( Enable_ST ));
AND2HDX0 I47 (.Q( net09 ), .B( Mag2_ST ), .A( Enable_ST ));
AND2HDX0 I48 (.Q( net011 ), .B( Mag3_ST ), .A( Enable_ST ));
AND2HDX0 I49 (.Q( net013 ), .B( Mag4_ST ), .A( Enable_ST ));
CurrentMirror_ST I2 (.\vdd3! (cds_globals.\vdd3! ), .\gnd! (cds_globals.\gnd! ), .Ist( Ist ), .Iref( net9 ), .vddh( vddh ), .enable( Enable_ST ));
Idac_5bit_ST_V3 I1 (.D4_3v( D4_3v ), .D3_3v( D3_3v ), .D1_3v( D1_3v ), .D2_3v( D2_3v ), .D0_3v( D0_3v ), .\vdd3! (cds_globals.\vdd3! ), .Iref( Iref ), .Idac( net9 ));
IN_3VX2 I31 (.A( net06 ), .Q( D0_3v ));
IN_3VX2 I15 (.A( net08 ), .Q( D1_3v ));
IN_3VX2 I13 (.A( net010 ), .Q( D2_3v ));
IN_3VX2 I11 (.A( net012 ), .Q( D3_3v ));
IN_3VX2 I10 (.A( net014 ), .Q( D4_3v ));
LSHVT18U3VX1 I16 (.A( net05 ), .Q( net06 ));
LSHVT18U3VX1 I30 (.A( net07 ), .Q( net08 ));
LSHVT18U3VX1 I14 (.A( net09 ), .Q( net010 ));
LSHVT18U3VX1 I12 (.A( net011 ), .Q( net012 ));
LSHVT18U3VX1 I29 (.A( net013 ), .Q( net014 ));

endmodule
// Library - Stimulator_IMP, Cell - ResistiveDivider, View - schematic
// LAST TIME SAVED: Apr  9 15:33:06 2021
// NETLIST TIME: May 13 15:52:39 2021

`worklib Stimulator_IMP
`view schematic

`timescale 1ns / 1ps
(* cds_ams_schematic *)

module ResistiveDivider (VOUT, V1, V2);
output  VOUT;
input  V1, V2;
rpp1k1 #(.l(2.3e-05), .w(2e-06), .m(1), .par1(1))
(* integer passed_mfactor = "m"; *)
 R37 (net09, V2);
rpp1k1 #(.l(2.3e-05), .w(2e-06), .m(1), .par1(1))
(* integer passed_mfactor = "m"; *)
 R36 (net010, net09);
rpp1k1 #(.l(2.3e-05), .w(2e-06), .m(1), .par1(1))
(* integer passed_mfactor = "m"; *)
 R35 (net011, net010);
rpp1k1 #(.l(2.3e-05), .w(2e-06), .m(1), .par1(1))
(* integer passed_mfactor = "m"; *)
 R34 (net012, net011);
rpp1k1 #(.l(2.3e-05), .w(2e-06), .m(1), .par1(1))
(* integer passed_mfactor = "m"; *)
 R33 (net013, net012);
rpp1k1 #(.l(2.3e-05), .w(2e-06), .m(1), .par1(1))
(* integer passed_mfactor = "m"; *)
 R32 (net014, net013);
rpp1k1 #(.l(2.3e-05), .w(2e-06), .m(1), .par1(1))
(* integer passed_mfactor = "m"; *)
 R31 (net015, net014);
rpp1k1 #(.l(2.3e-05), .w(2e-06), .m(1), .par1(1))
(* integer passed_mfactor = "m"; *)
 R30 (net016, net015);
rpp1k1 #(.l(2.3e-05), .w(2e-06), .m(1), .par1(1))
(* integer passed_mfactor = "m"; *)
 R29 (net017, net016);
rpp1k1 #(.l(2.3e-05), .w(2e-06), .m(1), .par1(1))
(* integer passed_mfactor = "m"; *)
 R28 (net018, net017);
rpp1k1 #(.l(2.3e-05), .w(2e-06), .m(1), .par1(1))
(* integer passed_mfactor = "m"; *)
 R27 (net019, net018);
rpp1k1 #(.l(2.3e-05), .w(2e-06), .m(1), .par1(1))
(* integer passed_mfactor = "m"; *)
 R26 (VOUT, net019);
rpp1k1 #(.l(2.3e-05), .w(2e-06), .m(1), .par1(1))
(* integer passed_mfactor = "m"; *)
 R25 (net020, VOUT);
rpp1k1 #(.l(2.3e-05), .w(2e-06), .m(1), .par1(1))
(* integer passed_mfactor = "m"; *)
 R24 (net021, net020);
rpp1k1 #(.l(2.3e-05), .w(2e-06), .m(1), .par1(1))
(* integer passed_mfactor = "m"; *)
 R23 (net022, net021);
rpp1k1 #(.l(2.3e-05), .w(2e-06), .m(1), .par1(1))
(* integer passed_mfactor = "m"; *)
 R22 (net023, net022);
rpp1k1 #(.l(2.3e-05), .w(2e-06), .m(1), .par1(1))
(* integer passed_mfactor = "m"; *)
 R21 (net024, net023);
rpp1k1 #(.l(2.3e-05), .w(2e-06), .m(1), .par1(1))
(* integer passed_mfactor = "m"; *)
 R20 (net025, net024);
rpp1k1 #(.l(2.3e-05), .w(2e-06), .m(1), .par1(1))
(* integer passed_mfactor = "m"; *)
 R19 (net026, net025);
rpp1k1 #(.l(2.3e-05), .w(2e-06), .m(1), .par1(1))
(* integer passed_mfactor = "m"; *)
 R18 (net027, net026);
rpp1k1 #(.l(2.3e-05), .w(2e-06), .m(1), .par1(1))
(* integer passed_mfactor = "m"; *)
 R17 (net028, net027);
rpp1k1 #(.l(2.3e-05), .w(2e-06), .m(1), .par1(1))
(* integer passed_mfactor = "m"; *)
 R16 (net029, net028);
rpp1k1 #(.l(2.3e-05), .w(2e-06), .m(1), .par1(1))
(* integer passed_mfactor = "m"; *)
 R15 (net030, net029);
rpp1k1 #(.l(2.3e-05), .w(2e-06), .m(1), .par1(1))
(* integer passed_mfactor = "m"; *)
 R14 (net031, net030);
rpp1k1 #(.l(2.3e-05), .w(2e-06), .m(1), .par1(1))
(* integer passed_mfactor = "m"; *)
 R13 (net032, net031);
rpp1k1 #(.l(2.3e-05), .w(2e-06), .m(1), .par1(1))
(* integer passed_mfactor = "m"; *)
 R12 (net033, net032);
rpp1k1 #(.l(2.3e-05), .w(2e-06), .m(1), .par1(1))
(* integer passed_mfactor = "m"; *)
 R11 (net034, net033);
rpp1k1 #(.l(2.3e-05), .w(2e-06), .m(1), .par1(1))
(* integer passed_mfactor = "m"; *)
 R10 (net035, net034);
rpp1k1 #(.l(2.3e-05), .w(2e-06), .m(1), .par1(1))
(* integer passed_mfactor = "m"; *)
 R9 (net036, net035);
rpp1k1 #(.l(2.3e-05), .w(2e-06), .m(1), .par1(1))
(* integer passed_mfactor = "m"; *)
 R8 (net037, net036);
rpp1k1 #(.l(2.3e-05), .w(2e-06), .m(1), .par1(1))
(* integer passed_mfactor = "m"; *)
 R7 (net038, net037);
rpp1k1 #(.l(2.3e-05), .w(2e-06), .m(1), .par1(1))
(* integer passed_mfactor = "m"; *)
 R6 (V1, net038);
rpp1k1 #(.l(2.3e-05), .w(2e-06), .m(1), .par1(1))
(* integer passed_mfactor = "m"; *)
 R5 (net08, net08);
rpp1k1 #(.l(2.3e-05), .w(2e-06), .m(1), .par1(1))
(* integer passed_mfactor = "m"; *)
 R4 (net07, net07);
rpp1k1 #(.l(2.3e-05), .w(2e-06), .m(1), .par1(1))
(* integer passed_mfactor = "m"; *)
 R3 (net5, net5);
rpp1k1 #(.l(2.3e-05), .w(2e-06), .m(1), .par1(1))
(* integer passed_mfactor = "m"; *)
 R2 (net6, net6);

endmodule
// Library - Stimulator_IMP, Cell - LS_HighSide_V3_ST, View - schematic
// LAST TIME SAVED: Apr  9 15:38:16 2021
// NETLIST TIME: May 13 15:52:39 2021

`worklib Stimulator_IMP
`view schematic

`timescale 1ns / 1ps
(* cds_ams_schematic *)

module LS_HighSide_V3_ST (out, .\gnd! (cdsNet2), .\vdd3! (cdsNet1), .\vdde! (cdsNet0), vddh, in);
output  out;
input  in;
inout  cdsNet2, cdsNet1, cdsNet0, vddh;
wire net10;
wire inn3v;
cds_alias #(1) cds_alias_inst7 ( cdsNet2 , cds_globals.\gnd! );
cds_alias #(1) cds_alias_inst8 ( cdsNet1 , cds_globals.\vdd3! );
cds_alias #(1) cds_alias_inst9 ( cdsNet0 , cds_globals.\vdde! );
ResistiveDivider I0 (.V2( net10 ), .V1( vddh ), .VOUT( out ));
LSHVT18U3VX1 I10 (.A( in ), .Q( inn3v ));
nedia_bjt #(.w(1.5e-05), .l(1.25e-06), .m((1)*(1)), .par1((1)*(1)), .extlay(0), .xf_subext(0))
(* integer passed_mfactor = "m"; *)
 M13 (net10, inn3v, cds_globals.\gnd! , cds_globals.\gnd! );

endmodule
// Library - Stimulator_IMP, Cell - LS_LowSide_V2_ST, View - schematic
// LAST TIME SAVED: Apr  9 15:57:59 2021
// NETLIST TIME: May 13 15:52:39 2021

`worklib Stimulator_IMP
`view schematic

`timescale 1ns / 1ps
(* cds_ams_schematic *)

module LS_LowSide_V2_ST (out, .\gnd! (cdsNet2), .\vdd3! (cdsNet1), .\vdde! (cdsNet0), vddh, in);
output  out;
input  in;
inout  cdsNet2, cdsNet1, cdsNet0, vddh;
wire net11;
wire net9;
cds_alias #(1) cds_alias_inst10 ( cdsNet2 , cds_globals.\gnd! );
cds_alias #(1) cds_alias_inst11 ( cdsNet1 , cds_globals.\vdd3! );
cds_alias #(1) cds_alias_inst12 ( cdsNet0 , cds_globals.\vdde! );
ResistiveDivider I2 (.V2(cds_globals.\gnd! ), .V1( net11 ), .VOUT( out ));
LS_HighSide_V3_ST I1 (.\vdde! (cds_globals.\vdde! ), .\gnd! (cds_globals.\gnd! ), .\vdd3! (cds_globals.\vdd3! ), .vddh( vddh ), .out( net9 ), .in( in ));
ped_bjt #(.w(2e-05), .l(9.4e-07), .m((1)*(1)), .par1((1)*(1)), .extlay(0), .xf_subext(0))
(* integer passed_mfactor = "m"; *)
 M1 (net11, net9, vddh, cds_globals.\gnd! );

endmodule
// Library - Stimulator_IMP, Cell - HalfBridge_ST, View - schematic
// LAST TIME SAVED: Apr  8 17:49:30 2021
// NETLIST TIME: May 13 15:52:39 2021

`worklib Stimulator_IMP
`view schematic

`timescale 1ns / 1ps
(* cds_ams_schematic *)

module HalfBridge_ST (OUT, Ist, .\gnd! (cdsNet2), .\vdd3! (cdsNet1), .\vdde! (cdsNet0), vddh, Ctrl_HS, Ctrl_LS);
output  OUT;
input  Ctrl_HS, Ctrl_LS;
inout  Ist, cdsNet2, cdsNet1, cdsNet0, vddh;
wire VG_ped;
wire VG_nedia;
cds_alias #(1) cds_alias_inst13 ( cdsNet2 , cds_globals.\gnd! );
cds_alias #(1) cds_alias_inst14 ( cdsNet1 , cds_globals.\vdd3! );
cds_alias #(1) cds_alias_inst15 ( cdsNet0 , cds_globals.\vdde! );
LS_HighSide_V3_ST I8 (.\vdde! (cds_globals.\vdde! ), .\gnd! (cds_globals.\gnd! ), .\vdd3! (cds_globals.\vdd3! ), .vddh( vddh ), .out( VG_ped ), .in( Ctrl_HS ));
LS_LowSide_V2_ST I9 (.\gnd! (cds_globals.\gnd! ), .\vdd3! (cds_globals.\vdd3! ), .\vdde! (cds_globals.\vdde! ), .vddh( vddh ), .out( VG_nedia ), .in( Ctrl_LS ));
nedia_bjt #(.w(8e-05), .l(1.25e-06), .m((1)*(10)), .par1((1)*(10)), .extlay(0), .xf_subext(0))
(* integer passed_mfactor = "m"; *)
 M34 (OUT, VG_nedia, Ist, cds_globals.\gnd! );
ped_bjt #(.w(8e-05), .l(9.4e-07), .m((1)*(13)), .par1((1)*(13)), .extlay(0), .xf_subext(0))
(* integer passed_mfactor = "m"; *)
 M66 (OUT, VG_ped, vddh, cds_globals.\gnd! );

endmodule
// Library - Stimulator_IMP, Cell - SingleChannel_ST, View - schematic
// LAST TIME SAVED: May  4 13:50:41 2021
// NETLIST TIME: May 13 15:52:39 2021

`worklib Stimulator_IMP
`view schematic

`timescale 1ns / 1ps
(* cds_ams_schematic *)

module SingleChannel_ST (Iext, .\gnd! (cdsNet2), out1, out2, .\vdd3! (cdsNet1), .\vdde! (cdsNet0), vddh, CtrlHS_1, CtrlHS_2, CtrlLS_1, CtrlLS_2, Enable_ST, Mag0_ST, Mag1_ST, Mag2_ST, Mag3_ST, Mag4_ST);
input  CtrlHS_1, CtrlHS_2, CtrlLS_1, CtrlLS_2, Enable_ST, Mag0_ST, Mag1_ST, Mag2_ST, Mag3_ST, Mag4_ST;
inout  Iext, cdsNet2, out1, out2, cdsNet1, cdsNet0, vddh;
wire net10;
cds_alias #(1) cds_alias_inst16 ( cdsNet2 , cds_globals.\gnd! );
cds_alias #(1) cds_alias_inst17 ( cdsNet1 , cds_globals.\vdd3! );
cds_alias #(1) cds_alias_inst18 ( cdsNet0 , cds_globals.\vdde! );
CurrentSource_All_ST I0 (.\gnd! (cds_globals.\gnd! ), .\vdd3! (cds_globals.\vdd3! ), .Ist( net10 ), .Iext( Iext ), .vddh( vddh ), .Enable_ST( Enable_ST ), .Mag0_ST( Mag0_ST ), .Mag1_ST( Mag1_ST ), .Mag2_ST( Mag2_ST ), .Mag3_ST( Mag3_ST ), .Mag4_ST( Mag4_ST ));
HalfBridge_ST I2 (.\vdd3! (cds_globals.\vdd3! ), .vddh( vddh ), .\vdde! (cds_globals.\vdde! ), .\gnd! (cds_globals.\gnd! ), .Ctrl_LS( CtrlLS_2 ), .Ctrl_HS( CtrlHS_2 ), .OUT( out2 ), .Ist( net10 ));
HalfBridge_ST I1 (.\vdd3! (cds_globals.\vdd3! ), .vddh( vddh ), .\vdde! (cds_globals.\vdde! ), .\gnd! (cds_globals.\gnd! ), .Ctrl_LS( CtrlLS_1 ), .Ctrl_HS( CtrlHS_1 ), .OUT( out1 ), .Ist( net10 ));

endmodule
// Library - Stimulator_IMP, Cell - CurrentMirror_x10_LV, View - schematic
// LAST TIME SAVED: Apr 23 15:21:29 2021
// NETLIST TIME: May 13 15:52:39 2021

`worklib Stimulator_IMP
`view schematic

`timescale 1ns / 1ps
(* cds_ams_schematic *)

module CurrentMirror_x10_LV (Iin, Ix10, .\gnd! (cdsNet0));
inout  Iin, Ix10, cdsNet0;
cds_alias #(1) cds_alias_inst1 ( cdsNet0 , cds_globals.\gnd! );
ne3 #(.w(1.2e-05), .l(3e-06), .as(5.76e-12), .ad(5.76e-12), .ps(2.496e-05), .pd(2.496e-05), .nrs(0.0225), .nrd(0.0225), .m((6)*(1)), .par1((6)*(1)), .xf_subext(0))
(* integer passed_mfactor = "m"; *)
 M26 (Iin, Iin, cds_globals.\gnd! , cds_globals.\gnd! );
ne3 #(.w(1.2e-05), .l(3e-06), .as(5.76e-12), .ad(5.76e-12), .ps(2.496e-05), .pd(2.496e-05), .nrs(0.0225), .nrd(0.0225), .m((60)*(1)), .par1((60)*(1)), .xf_subext(0))
(* integer passed_mfactor = "m"; *)
 M13 (Ix10, Iin, cds_globals.\gnd! , cds_globals.\gnd! );

endmodule
// Library - Stimulator_IMP, Cell - CurrentMirror_ST, View - schematic
// LAST TIME SAVED: Apr 23 17:12:47 2021
// NETLIST TIME: May 13 15:52:39 2021

`worklib Stimulator_IMP
`view schematic

`timescale 1ns / 1ps
(* cds_ams_schematic *)

module CurrentMirror_ST (Iref, Ist, .\gnd! (cdsNet1), .\vdd3! (cdsNet0), vddh, enable);
input  enable;
inout  Iref, Ist, cdsNet1, cdsNet0, vddh;
wire en_3v;
wire Iout_LV;
cds_alias #(1) cds_alias_inst2 ( cdsNet1 , cds_globals.\gnd! );
cds_alias #(1) cds_alias_inst3 ( cdsNet0 , cds_globals.\vdd3! );
LSHVT18U3VX2 I17 (.A( enable ), .Q( en_3v ));
CurrentMirror_x10_LV I0 (.\gnd! (cds_globals.\gnd! ), .Ix10( Iout_LV ), .Iin( Iref ));
csft5a #(.area(6.3936e-11), .perimeter(3.372e-05), .m(15), .par1(15))
(* integer passed_mfactor = "m"; *)
 C5 (vddh, Vmid);
csft5a #(.area(6.3936e-11), .perimeter(3.372e-05), .m(45), .par1(45))
(* integer passed_mfactor = "m"; *)
 C1 (Vmid, cds_globals.\gnd! );
nedia_bjt #(.w(1e-05), .l(1.25e-06), .m((1)*(1)), .par1((1)*(1)), .extlay(0), .xf_subext(0))
(* integer passed_mfactor = "m"; *)
 M17 (Iout_LV, Vmid, cds_globals.\gnd! , cds_globals.\gnd! );
nedia_bjt #(.w(1e-05), .l(1.25e-06), .m((1)*(1)), .par1((1)*(1)), .extlay(0), .xf_subext(0))
(* integer passed_mfactor = "m"; *)
 M15 (Vmid, cds_globals.\vdd3! , cds_globals.\gnd! , cds_globals.\gnd! );
nedia_bjt #(.w(4e-05), .l(1.25e-06), .m((1)*(1)), .par1((1)*(1)), .extlay(0), .xf_subext(0))
(* integer passed_mfactor = "m"; *)
 M14 (Iout2, Iout2, VG1, cds_globals.\gnd! );
nedia_bjt #(.w(8e-05), .l(1.25e-06), .m((1)*(1)), .par1((1)*(1)), .extlay(0), .xf_subext(0))
(* integer passed_mfactor = "m"; *)
 M8 (Iout1, Iout1, VB, cds_globals.\gnd! );
nedia_bjt #(.w(6e-05), .l(1.25e-06), .m((1)*(5)), .par1((1)*(5)), .extlay(0), .xf_subext(0))
(* integer passed_mfactor = "m"; *)
 M16 (Bias2, en_3v, Iout_LV, cds_globals.\gnd! );
nedia_bjt #(.w(8e-05), .l(1.25e-06), .m((1)*(1)), .par1((1)*(1)), .extlay(0), .xf_subext(0))
(* integer passed_mfactor = "m"; *)
 M5 (VG1, VB, VD_M4, cds_globals.\gnd! );
nedia_bjt #(.w(8e-05), .l(1.25e-06), .m((10)*(1)), .par1((10)*(1)), .extlay(0), .xf_subext(0))
(* integer passed_mfactor = "m"; *)
 M0 (Ist, VB, VD_M3, cds_globals.\gnd! );
nedia_bjt #(.w(3.5e-05), .l(1.25e-06), .m((1)*(1)), .par1((1)*(1)), .extlay(0), .xf_subext(0))
(* integer passed_mfactor = "m"; *)
 M7 (VB, Iout1, net16, cds_globals.\gnd! );
nedia_bjt #(.w(8e-05), .l(1.25e-06), .m((1)*(1)), .par1((1)*(1)), .extlay(0), .xf_subext(0))
(* integer passed_mfactor = "m"; *)
 M6 (net16, net16, cds_globals.\gnd! , cds_globals.\gnd! );
nedia_bjt #(.w(8e-05), .l(1.25e-06), .m((1)*(1)), .par1((1)*(1)), .extlay(0), .xf_subext(0))
(* integer passed_mfactor = "m"; *)
 M4 (VD_M4, VG1, cds_globals.\gnd! , cds_globals.\gnd! );
nedia_bjt #(.w(8e-05), .l(1.25e-06), .m((10)*(1)), .par1((10)*(1)), .extlay(0), .xf_subext(0))
(* integer passed_mfactor = "m"; *)
 M3 (VD_M3, VG1, cds_globals.\gnd! , cds_globals.\gnd! );
ped_bjt #(.w(3e-05), .l(9.4e-07), .m((1)*(1)), .par1((1)*(1)), .extlay(0), .xf_subext(0))
(* integer passed_mfactor = "m"; *)
 M11 (VD_M11, Bias1, vddh, cds_globals.\gnd! );
ped_bjt #(.w(3e-05), .l(9.4e-07), .m((1)*(1)), .par1((1)*(1)), .extlay(0), .xf_subext(0))
(* integer passed_mfactor = "m"; *)
 M1 (VD_M1, Bias1, vddh, cds_globals.\gnd! );
ped_bjt #(.w(3e-05), .l(9.4e-07), .m((1)*(1)), .par1((1)*(1)), .extlay(0), .xf_subext(0))
(* integer passed_mfactor = "m"; *)
 M2 (Bias1, Bias1, vddh, cds_globals.\gnd! );
ped_bjt #(.w(3e-05), .l(9.4e-07), .m((1)*(1)), .par1((1)*(1)), .extlay(0), .xf_subext(0))
(* integer passed_mfactor = "m"; *)
 M12 (Iout2, Bias2, VD_M11, cds_globals.\gnd! );
ped_bjt #(.w(3e-05), .l(9.4e-07), .m((1)*(1)), .par1((1)*(1)), .extlay(0), .xf_subext(0))
(* integer passed_mfactor = "m"; *)
 M10 (Iout1, Bias2, VD_M1, cds_globals.\gnd! );
ped_bjt #(.w(3e-05), .l(9.4e-07), .m((1)*(1)), .par1((1)*(1)), .extlay(0), .xf_subext(0))
(* integer passed_mfactor = "m"; *)
 M9 (Bias2, Bias2, Bias1, cds_globals.\gnd! );
rpp1k1 #(.l(0.00011122), .w(2e-06), .m(1), .par1(1))
(* integer passed_mfactor = "m"; *)
 R3 (net030, cds_globals.\gnd! );
rpp1k1 #(.l(0.00036998), .w(2e-06), .m(1), .par1(1))
(* integer passed_mfactor = "m"; *)
 R2 (cds_globals.\vdd3! , cds_globals.\gnd! );
rpp1k1 #(.l(0.00011122), .w(2e-06), .m(1), .par1(1))
(* integer passed_mfactor = "m"; *)
 R0 (en_3v, net030);

endmodule
// Library - Stimulator_IMP, Cell - Idac_5bit_ST_V3, View - schematic
// LAST TIME SAVED: Apr 26 14:24:45 2021
// NETLIST TIME: May 13 15:52:39 2021

`worklib Stimulator_IMP
`view schematic

`timescale 1ns / 1ps
(* cds_ams_schematic *)

module Idac_5bit_ST_V3 (Idac, Iref, .\vdd3! (cdsNet0), D0_3v, D1_3v, D2_3v, D3_3v, D4_3v);
input  D0_3v, D1_3v, D2_3v, D3_3v, D4_3v;
inout  Idac, Iref, cdsNet0;
cds_alias #(1) cds_alias_inst4 ( cdsNet0 , cds_globals.\vdd3! );
pe3 #(.w(6e-06), .l(2e-06), .as(2.88e-12), .ad(2.88e-12), .ps(1.296e-05), .pd(1.296e-05), .nrs(0.045), .nrd(0.045), .m((8)*(1)), .par1((8)*(1)))
(* integer passed_mfactor = "m"; *)
 M0 (cds_globals.\vdd3! , cds_globals.\vdd3! , cds_globals.\vdd3! , cds_globals.\vdd3! );
pe3 #(.w(6e-06), .l(2e-06), .as(2.88e-12), .ad(2.88e-12), .ps(1.296e-05), .pd(1.296e-05), .nrs(0.045), .nrd(0.045), .m((4)*(1)), .par1((4)*(1)))
(* integer passed_mfactor = "m"; *)
 M1 (Iref, Iref, Vbias, cds_globals.\vdd3! );
pe3 #(.w(2e-06), .l(3e-07), .as(6.45e-13), .ad(5.4e-13), .ps(3.145e-06), .pd(2.54e-06), .nrs(0.135), .nrd(0.135), .m((1)*(8)), .par1((1)*(8)))
(* integer passed_mfactor = "m"; *)
 M31 (Idac, D0_3v, Ix1, cds_globals.\vdd3! );
pe3 #(.w(6e-06), .l(2e-06), .as(2.88e-12), .ad(2.88e-12), .ps(1.296e-05), .pd(1.296e-05), .nrs(0.045), .nrd(0.045), .m((4)*(1)), .par1((4)*(1)))
(* integer passed_mfactor = "m"; *)
 M20 (n1, Vbias, cds_globals.\vdd3! , cds_globals.\vdd3! );
pe3 #(.w(6e-06), .l(2e-06), .as(2.88e-12), .ad(2.88e-12), .ps(1.296e-05), .pd(1.296e-05), .nrs(0.045), .nrd(0.045), .m((4)*(1)), .par1((4)*(1)))
(* integer passed_mfactor = "m"; *)
 M22 (Ix1, Iref, n1, cds_globals.\vdd3! );
pe3 #(.w(6e-06), .l(2e-06), .as(2.88e-12), .ad(2.88e-12), .ps(1.296e-05), .pd(1.296e-05), .nrs(0.045), .nrd(0.045), .m((8)*(1)), .par1((8)*(1)))
(* integer passed_mfactor = "m"; *)
 M23 (n2, Vbias, cds_globals.\vdd3! , cds_globals.\vdd3! );
pe3 #(.w(6e-06), .l(2e-06), .as(2.88e-12), .ad(2.88e-12), .ps(1.296e-05), .pd(1.296e-05), .nrs(0.045), .nrd(0.045), .m((8)*(1)), .par1((8)*(1)))
(* integer passed_mfactor = "m"; *)
 M24 (Ix2, Iref, n2, cds_globals.\vdd3! );
pe3 #(.w(6e-06), .l(2e-06), .as(2.88e-12), .ad(2.88e-12), .ps(1.296e-05), .pd(1.296e-05), .nrs(0.045), .nrd(0.045), .m((16)*(1)), .par1((16)*(1)))
(* integer passed_mfactor = "m"; *)
 M25 (n3, Vbias, cds_globals.\vdd3! , cds_globals.\vdd3! );
pe3 #(.w(6e-06), .l(2e-06), .as(2.88e-12), .ad(2.88e-12), .ps(1.296e-05), .pd(1.296e-05), .nrs(0.045), .nrd(0.045), .m((16)*(1)), .par1((16)*(1)))
(* integer passed_mfactor = "m"; *)
 M29 (Ix4, Iref, n3, cds_globals.\vdd3! );
pe3 #(.w(6e-06), .l(2e-06), .as(2.88e-12), .ad(2.88e-12), .ps(1.296e-05), .pd(1.296e-05), .nrs(0.045), .nrd(0.045), .m((32)*(1)), .par1((32)*(1)))
(* integer passed_mfactor = "m"; *)
 M32 (Ix8, Iref, n4, cds_globals.\vdd3! );
pe3 #(.w(6e-06), .l(2e-06), .as(2.88e-12), .ad(2.88e-12), .ps(1.296e-05), .pd(1.296e-05), .nrs(0.045), .nrd(0.045), .m((32)*(1)), .par1((32)*(1)))
(* integer passed_mfactor = "m"; *)
 M33 (n4, Vbias, cds_globals.\vdd3! , cds_globals.\vdd3! );
pe3 #(.w(6e-06), .l(2e-06), .as(2.88e-12), .ad(2.88e-12), .ps(1.296e-05), .pd(1.296e-05), .nrs(0.045), .nrd(0.045), .m((64)*(1)), .par1((64)*(1)))
(* integer passed_mfactor = "m"; *)
 M35 (n5, Vbias, cds_globals.\vdd3! , cds_globals.\vdd3! );
pe3 #(.w(6e-06), .l(2e-06), .as(2.88e-12), .ad(2.88e-12), .ps(1.296e-05), .pd(1.296e-05), .nrs(0.045), .nrd(0.045), .m((64)*(1)), .par1((64)*(1)))
(* integer passed_mfactor = "m"; *)
 M36 (Ix16, Iref, n5, cds_globals.\vdd3! );
pe3 #(.w(6e-06), .l(2e-06), .as(2.88e-12), .ad(2.88e-12), .ps(1.296e-05), .pd(1.296e-05), .nrs(0.045), .nrd(0.045), .m((4)*(1)), .par1((4)*(1)))
(* integer passed_mfactor = "m"; *)
 M38 (Vbias, Vbias, cds_globals.\vdd3! , cds_globals.\vdd3! );
pe3 #(.w(2e-06), .l(3e-07), .as(6.45e-13), .ad(5.4e-13), .ps(3.145e-06), .pd(2.54e-06), .nrs(0.135), .nrd(0.135), .m((1)*(8)), .par1((1)*(8)))
(* integer passed_mfactor = "m"; *)
 M39 (Idac, D1_3v, Ix2, cds_globals.\vdd3! );
pe3 #(.w(2e-06), .l(3e-07), .as(6.45e-13), .ad(5.4e-13), .ps(3.145e-06), .pd(2.54e-06), .nrs(0.135), .nrd(0.135), .m((1)*(8)), .par1((1)*(8)))
(* integer passed_mfactor = "m"; *)
 M40 (Idac, D2_3v, Ix4, cds_globals.\vdd3! );
pe3 #(.w(2e-06), .l(3e-07), .as(6.45e-13), .ad(5.4e-13), .ps(3.145e-06), .pd(2.54e-06), .nrs(0.135), .nrd(0.135), .m((1)*(8)), .par1((1)*(8)))
(* integer passed_mfactor = "m"; *)
 M41 (Idac, D3_3v, Ix8, cds_globals.\vdd3! );
pe3 #(.w(2e-06), .l(3e-07), .as(6.45e-13), .ad(5.4e-13), .ps(3.145e-06), .pd(2.54e-06), .nrs(0.135), .nrd(0.135), .m((1)*(8)), .par1((1)*(8)))
(* integer passed_mfactor = "m"; *)
 M42 (Idac, D4_3v, Ix16, cds_globals.\vdd3! );

endmodule
// Library - D_CELLS_HD, Cell - AND2HDX0, View - cmos_sch
// LAST TIME SAVED: Jan 23 08:10:19 2018
// NETLIST TIME: May 13 15:52:39 2021

`worklib D_CELLS_HD
`view cmos_sch

`timescale 1ns / 1ps
(* cds_ams_schematic *)

module AND2HDX0 (Q, A, B);
output  Q;
input  A, B;
wire (*
integer inh_conn_prop_name = "ground_gnd";
integer inh_conn_def_value = "cds_globals.\\gnd! "; *)
\gnd! ;
wire (*
integer inh_conn_prop_name = "power_vdd";
integer inh_conn_def_value = "cds_globals.\\vdd! "; *)
\vdd! ;
wire net10;
nand2 #(.sx(4.8e-07), .GT_PUW(7.2e-07), .GT_PDL(1.8e-07), .lc(2.7e-07), .GT_PUL(1.8e-07), .GT_PDW(4.2e-07)) nand2_1 (.a( A ), .b( B ), .out( net10 ));
invr #(.sx(4.8e-07), .GT_PUW(7.2e-07), .GT_PDL(1.8e-07), .lc(2.7e-07), .GT_PUL(1.8e-07), .GT_PDW(4.2e-07)) invr_1 (.out( Q ), .in( net10 ));

endmodule
// Library - GATES_3V, Cell - invrv3, View - schematic
// LAST TIME SAVED: Mar  7 12:42:39 2018
// NETLIST TIME: May 13 15:52:39 2021

`worklib GATES_3V
`view schematic

`timescale 1ns / 1ps
(* cds_ams_schematic *)

module invrv3 (out, in);
output  out;
input  in;
wire (*
integer inh_conn_prop_name = "power_vdd3";
integer inh_conn_def_value = "cds_globals.\\vdd3! "; *)
\vdd3! ;
wire (*
integer inh_conn_prop_name = "ground_gnd";
integer inh_conn_def_value = "cds_globals.\\gnd! "; *)
\gnd! ;
parameter GT_PDW=0 ;
parameter GT_PDL=3.5e-07 ;
parameter sx=4.8e-07 ;
parameter lc=2.7e-07 ;
parameter GT_PUW=0 ;
parameter GT_PUL=3e-07 ;
ne3 #(.w(GT_PDW), .l(GT_PDL), .as(sx*(GT_PDW)), .ad(sx*(GT_PDW)), .ps(2*sx+(GT_PDW)), .pd(2*sx+(GT_PDW)), .nrs(lc/(GT_PDW)), .nrd(lc/(GT_PDW)), .m((1)*(1)), .par1((1)*(1)), .xf_subext(0))
(* integer passed_mfactor = "m"; *)
 MN1 (out, in, \gnd! , \gnd! );
pe3 #(.w(GT_PUW), .l(GT_PUL), .as(sx*(GT_PUW)), .ad(sx*(GT_PUW)), .ps(2*sx+(GT_PUW)), .pd(2*sx+(GT_PUW)), .nrs(lc/(GT_PUW)), .nrd(lc/(GT_PUW)), .m((1)*(1)), .par1((1)*(1)))
(* integer passed_mfactor = "m"; *)
 MP1 (out, in, \vdd3! , \vdd3! );

endmodule
// Library - D_CELLS_3V, Cell - IN_3VX2, View - cmos_sch
// LAST TIME SAVED: Feb 20 10:23:55 2018
// NETLIST TIME: May 13 15:52:39 2021

`worklib D_CELLS_3V
`view cmos_sch

`timescale 1ns / 1ps
(* cds_ams_schematic *)

module IN_3VX2 (Q, A);
output  Q;
input  A;
wire (*
integer inh_conn_prop_name = "power_vdd3";
integer inh_conn_def_value = "cds_globals.\\vdd3! "; *)
\vdd3! ;
wire (*
integer inh_conn_prop_name = "ground_gnd";
integer inh_conn_def_value = "cds_globals.\\gnd! "; *)
\gnd! ;
invrv3 #(.sx(4.8e-07), .GT_PUW(2.94e-06), .GT_PDL(3.5e-07), .lc(2.7e-07), .GT_PUL(3e-07), .GT_PDW(9.6e-07)) invr_1 (.in( A ), .out( Q ));

endmodule
// Library - EMG_Model, Cell - AFE_EMG, View - schematic
// LAST TIME SAVED: Feb  9 12:37:09 2021
// NETLIST TIME: May 13 15:52:39 2021

`worklib EMG_Model
`view schematic

`timescale 1ns / 1ps
(* cds_ams_schematic *)

module AFE_EMG (Vout, Ibias, Vdda, Vddd, Vssa, Vssd, Vsub, Gain_Sel, Vinn, Vinp);
output  Vout;
input  Vinn, Vinp;
inout  Ibias, Vdda, Vddd, Vssa, Vssd, Vsub;
input [2:0] Gain_Sel;
wire Voutp_IA;
wire Voutn_IA;
wire Voutp_BPF;
wire Voutn_BPF;
BPF_EMG I1 (.Ibias( Ibias ), .Vdda( Vdda ), .Vssa( Vssa ), .Vsub( Vsub ), .Voutn( Voutn_BPF ), .Voutp( Voutp_BPF ), .Vinn( Voutn_IA ), .Vinp( Voutp_IA ));
PGA_EMG I2 (.Vddd( Vddd ), .Vssd( Vssd ), .Ibias( Ibias ), .Vdda( Vdda ), .Vssa( Vssa ), .Vsub( Vsub ), .Vout( Vout ), .Gain_Sel( Gain_Sel ), .Vinn( Voutn_BPF ), .Vinp( Voutp_BPF ));
IA_EMG_Ideal I0 (.Ibias( Ibias ), .Vdda( Vdda ), .Vssa( Vssa ), .Vsub( Vsub ), .Voutn( Voutn_IA ), .Voutp( Voutp_IA ), .Vinn( Vinn ), .Vinp( Vinp ));

endmodule
// Library - EMG_NMES_TestBench, Cell - Sim_StimulusArtifact, View - schematic
// LAST TIME SAVED: May 13 15:48:59 2021
// NETLIST TIME: May 13 15:52:39 2021

`worklib EMG_NMES_TestBench
`view schematic

`timescale 1ns / 1ps
(* cds_ams_schematic *)

module Sim_StimulusArtifact ( );
wire [2:0] ChSel_HS;
wire [2:0] ChSel_LS;
wire [7:0] CtrlLS;
wire [7:0] CtrlHS;
wire [2:0] Gain_Sel;
wire [4:0] Mag_ST;
wire Enable_ST;
wire Vinp;
wire Vout;
wire vsub;
wire vssa;
wire vdda;
wire net4;
wire vssd;
wire vddh;
wire E10;
wire E00;
wire net025;
Decoder3_8 I35 (.Dout( CtrlHS ), .Bin( ChSel_HS ), .Enable( Enable_ST ));
Decoder3_8 I33 (.Dout( CtrlLS ), .Bin( ChSel_LS ), .Enable( Enable_ST ));
AFE_EMG I1 (.Vddd(cds_globals.\vdd! ), .Vssd( vssd ), .Ibias( net4 ), .Vdda( vdda ), .Vssa( vssa ), .Vsub( vsub ), .Vout( Vout ), .Gain_Sel( Gain_Sel[2:0] ), .Vinn(cds_globals.\gnd! ), .Vinp( Vinp ));
SingleChannel_ST I0 (.\gnd! (cds_globals.\gnd! ), .\vdd3! (cds_globals.\vdd3! ), .\vdde! (cds_globals.\vdde! ), .Iext( net025 ), .out1( E00 ), .out2( E10 ), .vddh( vddh ), .CtrlHS_1( CtrlHS[0] ), .CtrlHS_2( CtrlHS[1] ), .CtrlLS_1( CtrlLS[0] ), .CtrlLS_2( CtrlLS[1] ), .Enable_ST( Enable_ST ), .Mag0_ST( Mag_ST[0] ), .Mag1_ST( Mag_ST[1] ), .Mag2_ST( Mag_ST[2] ), .Mag3_ST( Mag_ST[3] ), .Mag4_ST( Mag_ST[4] ));
Digital_Stimulus_V2_ST #(.MAG(5'b11100), .InterPulseDelay(cds_globals.IPD), .Ch_ANO(3'b000), .ANO_phase(cds_globals.Tano), .Ch_CAT(3'b001), .CAT_phase(cds_globals.Tcat), .ST_period(cds_globals.Period)) I34 (.ChSel_HS( ChSel_HS ), .ChSel_LS( ChSel_LS ), .EN_ST( Enable_ST ), .MAG_ST( Mag_ST ));
resistor #(.r(1000)) R6 (Vinp, net09);
resistor #(.r(1000)) R9 (net017, net09);
resistor #(.r(1000)) R5 (E10, net016);
resistor #(.r(1000)) R4 (net017, net016);
resistor #(.r(1000)) R3 (E00, net017);
isource #(.dc(1e-05), .type("dc")) I36 (cds_globals.\vdd3! , net025);
isource #(.dc(1e-05), .type("dc")) I5 (vdda, net4);
vsource #(.dc(1.8), .type("dc")) V0 (cds_globals.\vdde! , cds_globals.\gnd! );
vsource #(.dc(1.8), .type("dc")) V29 (Gain_Sel[2], cds_globals.\gnd! );
vsource #(.dc(1.8), .type("dc")) V3 (cds_globals.\vdd! , cds_globals.\gnd! );
vsource #(.dc(0), .type("dc")) V19 (vssd, cds_globals.\gnd! );
vsource #(.dc(0), .type("dc")) V28 (Gain_Sel[1], cds_globals.\gnd! );
vsource #(.dc(0), .type("dc")) V27 (Gain_Sel[0], cds_globals.\gnd! );
vsource #(.dc(3.3), .type("dc")) V25 (cds_globals.\vdd3! , cds_globals.\gnd! );
vsource #(.dc(40), .type("dc")) V26 (vddh, cds_globals.\gnd! );
vsource #(.dc(0), .type("dc")) V6 (vssa, cds_globals.\gnd! );
vsource #(.dc(1.8), .type("dc")) V2 (vdda, cds_globals.\gnd! );
vsource #(.dc(0), .type("dc")) V4 (vsub, cds_globals.\gnd! );
capacitor #(.c(1e-09)) C1 (Vinp, net09);
capacitor #(.c(1e-09)) C3 (E10, net016);
capacitor #(.c(1e-09)) C2 (E00, net017);

endmodule
// Library - GATES_HD, Cell - nand2, View - schematic
// LAST TIME SAVED: Jan 18 15:00:04 2018
// NETLIST TIME: May 13 15:52:39 2021

`worklib GATES_HD
`view schematic

`timescale 1ns / 1ps
(* cds_ams_schematic *)

module nand2 (out, a, b);
output  out;
input  a, b;
wire (*
integer inh_conn_prop_name = "ground_gnd";
integer inh_conn_def_value = "cds_globals.\\gnd! "; *)
\gnd! ;
wire (*
integer inh_conn_prop_name = "power_vdd";
integer inh_conn_def_value = "cds_globals.\\vdd! "; *)
\vdd! ;
parameter GT_PDW=0 ;
parameter GT_PDL=1.8e-07 ;
parameter sx=4.8e-07 ;
parameter lc=2.7e-07 ;
parameter GT_PUW=0 ;
parameter GT_PUL=1.8e-07 ;
ne #(.w(GT_PDW), .l(GT_PDL), .as(sx*(GT_PDW)), .ad(sx*(GT_PDW)), .ps(2*(sx+(GT_PDW))), .pd(2*(sx+(GT_PDW))), .nrs(lc/(GT_PDW)), .nrd(lc/(GT_PDW)), .m((1)*(1)), .par1((1)*(1)), .xf_subext(0))
(* integer passed_mfactor = "m"; *)
 MN1 (out, a, net11, \gnd! );
ne #(.w(GT_PDW), .l(GT_PDL), .as(sx*(GT_PDW)), .ad(sx*(GT_PDW)), .ps(2*(sx+(GT_PDW))), .pd(2*(sx+(GT_PDW))), .nrs(lc/(GT_PDW)), .nrd(lc/(GT_PDW)), .m((1)*(1)), .par1((1)*(1)), .xf_subext(0))
(* integer passed_mfactor = "m"; *)
 MN2 (net11, b, \gnd! , \gnd! );
pe #(.w(GT_PUW), .l(GT_PUL), .as(sx*(GT_PUW)), .ad(sx*(GT_PUW)), .ps(2*(sx+(GT_PUW))), .pd(2*(sx+(GT_PUW))), .nrs(lc/(GT_PUW)), .nrd(lc/(GT_PUW)), .m((1)*(1)), .par1((1)*(1)))
(* integer passed_mfactor = "m"; *)
 MP1 (out, a, \vdd! , \vdd! );
pe #(.w(GT_PUW), .l(GT_PUL), .as(sx*(GT_PUW)), .ad(sx*(GT_PUW)), .ps(2*(sx+(GT_PUW))), .pd(2*(sx+(GT_PUW))), .nrs(lc/(GT_PUW)), .nrd(lc/(GT_PUW)), .m((1)*(1)), .par1((1)*(1)))
(* integer passed_mfactor = "m"; *)
 MP2 (out, b, \vdd! , \vdd! );

endmodule
// Library - GATES_HD, Cell - invr, View - schematic
// LAST TIME SAVED: Jan 18 15:00:13 2018
// NETLIST TIME: May 13 15:52:39 2021

`worklib GATES_HD
`view schematic

`timescale 1ns / 1ps
(* cds_ams_schematic *)

module invr (out, in);
output  out;
input  in;
wire (*
integer inh_conn_prop_name = "ground_gnd";
integer inh_conn_def_value = "cds_globals.\\gnd! "; *)
\gnd! ;
wire (*
integer inh_conn_prop_name = "power_vdd";
integer inh_conn_def_value = "cds_globals.\\vdd! "; *)
\vdd! ;
parameter GT_PDW=0 ;
parameter GT_PDL=1.8e-07 ;
parameter sx=4.8e-07 ;
parameter lc=2.7e-07 ;
parameter GT_PUW=0 ;
parameter GT_PUL=1.8e-07 ;
ne #(.w(GT_PDW), .l(GT_PDL), .as(sx*(GT_PDW)), .ad(sx*(GT_PDW)), .ps(2*(sx+(GT_PDW))), .pd(2*(sx+(GT_PDW))), .nrs(lc/(GT_PDW)), .nrd(lc/(GT_PDW)), .m((1)*(1)), .par1((1)*(1)), .xf_subext(0))
(* integer passed_mfactor = "m"; *)
 ne (out, in, \gnd! , \gnd! );
pe #(.w(GT_PUW), .l(GT_PUL), .as(sx*(GT_PUW)), .ad(sx*(GT_PUW)), .ps(2*(sx+(GT_PUW))), .pd(2*(sx+(GT_PUW))), .nrs(lc/(GT_PUW)), .nrd(lc/(GT_PUW)), .m((1)*(1)), .par1((1)*(1)))
(* integer passed_mfactor = "m"; *)
 pe (out, in, \vdd! , \vdd! );

endmodule
// Library - D_CELLS_M3V, Cell - LSHVT18U3VX1, View - cmos_sch
// LAST TIME SAVED: Jun  7 14:44:58 2018
// NETLIST TIME: May 13 15:52:39 2021

`worklib D_CELLS_M3V
`view cmos_sch

`timescale 1ns / 1ps
(* cds_ams_schematic *)

module LSHVT18U3VX1 (Q, A);
output  Q;
input  A;
wire (*
integer inh_conn_prop_name = "power_vdd3";
integer inh_conn_def_value = "cds_globals.\\vdd3! "; *)
\vdd3! ;
wire (*
integer inh_conn_prop_name = "ground_gnd";
integer inh_conn_def_value = "cds_globals.\\gnd! "; *)
\gnd! ;
wire (*
integer inh_conn_prop_name = "power_vdde";
integer inh_conn_def_value = "cds_globals.\\vdde! "; *)
\vdde! ;
pe3 #(.w(1.46e-06), .l(3e-07), .as(7.008e-13), .ad(7.008e-13), .ps(3.88e-06), .pd(3.88e-06), .nrs(0.184932), .nrd(0.184932), .m((1)*(1)), .par1((1)*(1)))
(* integer passed_mfactor = "m"; *)
 M6 (Q, net20, \vdd3! , \vdd3! );
pe3 #(.w(1.48e-06), .l(3e-07), .as(7.104e-13), .ad(7.104e-13), .ps(3.92e-06), .pd(3.92e-06), .nrs(0.182432), .nrd(0.182432), .m((1)*(1)), .par1((1)*(1)))
(* integer passed_mfactor = "m"; *)
 M8 (net4, A, \vdde! , \vdd3! );
pe3 #(.w(4.2e-07), .l(3e-07), .as(2.016e-13), .ad(2.016e-13), .ps(1.8e-06), .pd(1.8e-06), .nrs(0.642857), .nrd(0.642857), .m((1)*(1)), .par1((1)*(1)))
(* integer passed_mfactor = "m"; *)
 M9 (net20, A, net024, \vdd3! );
pe3 #(.w(4.2e-07), .l(3e-07), .as(2.016e-13), .ad(2.016e-13), .ps(1.8e-06), .pd(1.8e-06), .nrs(0.642857), .nrd(0.642857), .m((1)*(1)), .par1((1)*(1)))
(* integer passed_mfactor = "m"; *)
 M0 (net10, net4, net023, \vdd3! );
pe3 #(.w(4.2e-07), .l(3e-07), .as(2.016e-13), .ad(2.016e-13), .ps(1.8e-06), .pd(1.8e-06), .nrs(0.642857), .nrd(0.642857), .m((1)*(1)), .par1((1)*(1)))
(* integer passed_mfactor = "m"; *)
 M2 (net023, net20, \vdd3! , \vdd3! );
pe3 #(.w(4.2e-07), .l(3e-07), .as(2.016e-13), .ad(2.016e-13), .ps(1.8e-06), .pd(1.8e-06), .nrs(0.642857), .nrd(0.642857), .m((1)*(1)), .par1((1)*(1)))
(* integer passed_mfactor = "m"; *)
 M4 (net024, net10, \vdd3! , \vdd3! );
ne3 #(.w(1.31e-06), .l(3.5e-07), .as(6.288e-13), .ad(6.288e-13), .ps(3.58e-06), .pd(3.58e-06), .nrs(0.206107), .nrd(0.206107), .m((1)*(1)), .par1((1)*(1)), .xf_subext(0))
(* integer passed_mfactor = "m"; *)
 M3 (net20, A, \gnd! , \gnd! );
ne3 #(.w(8.9e-07), .l(3.5e-07), .as(4.272e-13), .ad(4.272e-13), .ps(2.74e-06), .pd(2.74e-06), .nrs(0.303371), .nrd(0.303371), .m((1)*(1)), .par1((1)*(1)), .xf_subext(0))
(* integer passed_mfactor = "m"; *)
 M5 (Q, net20, \gnd! , \gnd! );
ne3 #(.w(4.2e-07), .l(3.5e-07), .as(2.016e-13), .ad(2.016e-13), .ps(1.8e-06), .pd(1.8e-06), .nrs(0.642857), .nrd(0.642857), .m((1)*(1)), .par1((1)*(1)), .xf_subext(0))
(* integer passed_mfactor = "m"; *)
 M7 (net4, A, \gnd! , \gnd! );
ne3 #(.w(1.31e-06), .l(3.5e-07), .as(6.288e-13), .ad(6.288e-13), .ps(3.58e-06), .pd(3.58e-06), .nrs(0.206107), .nrd(0.206107), .m((1)*(1)), .par1((1)*(1)), .xf_subext(0))
(* integer passed_mfactor = "m"; *)
 M1 (net10, net4, \gnd! , \gnd! );

endmodule
// Library - D_CELLS_M3V, Cell - LSHVT18U3VX2, View - cmos_sch
// LAST TIME SAVED: Jun  7 14:44:51 2018
// NETLIST TIME: May 13 15:52:39 2021

`worklib D_CELLS_M3V
`view cmos_sch

`timescale 1ns / 1ps
(* cds_ams_schematic *)

module LSHVT18U3VX2 (Q, A);
output  Q;
input  A;
wire (*
integer inh_conn_prop_name = "power_vdd3";
integer inh_conn_def_value = "cds_globals.\\vdd3! "; *)
\vdd3! ;
wire (*
integer inh_conn_prop_name = "ground_gnd";
integer inh_conn_def_value = "cds_globals.\\gnd! "; *)
\gnd! ;
wire (*
integer inh_conn_prop_name = "power_vdde";
integer inh_conn_def_value = "cds_globals.\\vdde! "; *)
\vdde! ;
pe3 #(.w(2.82e-06), .l(3e-07), .as(1.3536e-12), .ad(1.3536e-12), .ps(6.6e-06), .pd(6.6e-06), .nrs(0.0957447), .nrd(0.0957447), .m((1)*(1)), .par1((1)*(1)))
(* integer passed_mfactor = "m"; *)
 M6 (Q, net20, \vdd3! , \vdd3! );
pe3 #(.w(1.47e-06), .l(3e-07), .as(7.056e-13), .ad(7.056e-13), .ps(3.9e-06), .pd(3.9e-06), .nrs(0.183673), .nrd(0.183673), .m((1)*(1)), .par1((1)*(1)))
(* integer passed_mfactor = "m"; *)
 M8 (net4, A, \vdde! , \vdd3! );
pe3 #(.w(4.2e-07), .l(3e-07), .as(2.016e-13), .ad(2.016e-13), .ps(1.8e-06), .pd(1.8e-06), .nrs(0.642857), .nrd(0.642857), .m((1)*(1)), .par1((1)*(1)))
(* integer passed_mfactor = "m"; *)
 M9 (net20, A, net024, \vdd3! );
pe3 #(.w(4.2e-07), .l(3e-07), .as(2.016e-13), .ad(2.016e-13), .ps(1.8e-06), .pd(1.8e-06), .nrs(0.642857), .nrd(0.642857), .m((1)*(1)), .par1((1)*(1)))
(* integer passed_mfactor = "m"; *)
 M0 (net10, net4, net023, \vdd3! );
pe3 #(.w(4.2e-07), .l(3e-07), .as(2.016e-13), .ad(2.016e-13), .ps(1.8e-06), .pd(1.8e-06), .nrs(0.642857), .nrd(0.642857), .m((1)*(1)), .par1((1)*(1)))
(* integer passed_mfactor = "m"; *)
 M2 (net023, net20, \vdd3! , \vdd3! );
pe3 #(.w(4.2e-07), .l(3e-07), .as(2.016e-13), .ad(2.016e-13), .ps(1.8e-06), .pd(1.8e-06), .nrs(0.642857), .nrd(0.642857), .m((1)*(1)), .par1((1)*(1)))
(* integer passed_mfactor = "m"; *)
 M4 (net024, net10, \vdd3! , \vdd3! );
ne3 #(.w(1.31e-06), .l(3.5e-07), .as(6.288e-13), .ad(6.288e-13), .ps(3.58e-06), .pd(3.58e-06), .nrs(0.206107), .nrd(0.206107), .m((1)*(1)), .par1((1)*(1)), .xf_subext(0))
(* integer passed_mfactor = "m"; *)
 M3 (net20, A, \gnd! , \gnd! );
ne3 #(.w(1.78e-06), .l(3.5e-07), .as(8.544e-13), .ad(8.544e-13), .ps(4.52e-06), .pd(4.52e-06), .nrs(0.151685), .nrd(0.151685), .m((1)*(1)), .par1((1)*(1)), .xf_subext(0))
(* integer passed_mfactor = "m"; *)
 M5 (Q, net20, \gnd! , \gnd! );
ne3 #(.w(4.2e-07), .l(3.5e-07), .as(2.016e-13), .ad(2.016e-13), .ps(1.8e-06), .pd(1.8e-06), .nrs(0.642857), .nrd(0.642857), .m((1)*(1)), .par1((1)*(1)), .xf_subext(0))
(* integer passed_mfactor = "m"; *)
 M7 (net4, A, \gnd! , \gnd! );
ne3 #(.w(1.31e-06), .l(3.5e-07), .as(6.288e-13), .ad(6.288e-13), .ps(3.58e-06), .pd(3.58e-06), .nrs(0.206107), .nrd(0.206107), .m((1)*(1)), .par1((1)*(1)), .xf_subext(0))
(* integer passed_mfactor = "m"; *)
 M1 (net10, net4, \gnd! , \gnd! );

endmodule
`noworklib
`noview
