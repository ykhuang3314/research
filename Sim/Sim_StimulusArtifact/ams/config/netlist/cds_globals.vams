// Verilog-AMS cds_globals module for top-level cell:
//    EMG_NMES_TestBench/Sim_StimulusArtifact.
// Generated by ADE.
// Cadence Design Systems, Inc.

// This is an autoGenerated file, any changes done to this file may get lost.

`include "disciplines.vams"
`include "userDisciplines.vams"

module cds_globals;

// Global Signals
   electrical \gnd! ;
   ground \gnd! ;
   wire \vdd! ;
   wire \vdde! ;
   wire \vdd3! ;

// Design Variables
   dynamicparam real Period = 1000;
   dynamicparam real Tcat = 300;
   dynamicparam real Tano = 300;
   dynamicparam real IPD = 100;

endmodule
