// AMS netlist generated by the AMS Unified netlister
// IC subversion:  IC6.1.8-64b.500.7
// Xcelium version: 18.03-s018
// Copyright(C) 2005-2009, Cadence Design Systems, Inc
// User: ykhuang Pid: 13727
// Design library name: Stimulator_TestBench
// Design cell name: TB_OneChannel_imp
// Design view name: config
// Solver: Spectre

`include "disciplines.vams"
`include "userDisciplines.vams"
// HDL file - Stimulator_IMP, Digital_Stimulus_ST, functional.
// Library - Stimulator_IMP, Cell - ResistiveDivider, View - schematic
// LAST TIME SAVED: Apr  9 15:33:06 2021
// NETLIST TIME: Apr 30 15:39:15 2021

`worklib Stimulator_IMP
`view schematic

`timescale 1ns / 1ps
(* cds_ams_schematic *)

module ResistiveDivider (VOUT, V1, V2);
output  VOUT;
input  V1, V2;
rpp1k1 #(.l(2.3e-05), .w(2e-06), .m(1), .par1(1))
(* integer passed_mfactor = "m"; *)
 R37 (net09, V2);
rpp1k1 #(.l(2.3e-05), .w(2e-06), .m(1), .par1(1))
(* integer passed_mfactor = "m"; *)
 R36 (net010, net09);
rpp1k1 #(.l(2.3e-05), .w(2e-06), .m(1), .par1(1))
(* integer passed_mfactor = "m"; *)
 R35 (net011, net010);
rpp1k1 #(.l(2.3e-05), .w(2e-06), .m(1), .par1(1))
(* integer passed_mfactor = "m"; *)
 R34 (net012, net011);
rpp1k1 #(.l(2.3e-05), .w(2e-06), .m(1), .par1(1))
(* integer passed_mfactor = "m"; *)
 R33 (net013, net012);
rpp1k1 #(.l(2.3e-05), .w(2e-06), .m(1), .par1(1))
(* integer passed_mfactor = "m"; *)
 R32 (net014, net013);
rpp1k1 #(.l(2.3e-05), .w(2e-06), .m(1), .par1(1))
(* integer passed_mfactor = "m"; *)
 R31 (net015, net014);
rpp1k1 #(.l(2.3e-05), .w(2e-06), .m(1), .par1(1))
(* integer passed_mfactor = "m"; *)
 R30 (net016, net015);
rpp1k1 #(.l(2.3e-05), .w(2e-06), .m(1), .par1(1))
(* integer passed_mfactor = "m"; *)
 R29 (net017, net016);
rpp1k1 #(.l(2.3e-05), .w(2e-06), .m(1), .par1(1))
(* integer passed_mfactor = "m"; *)
 R28 (net018, net017);
rpp1k1 #(.l(2.3e-05), .w(2e-06), .m(1), .par1(1))
(* integer passed_mfactor = "m"; *)
 R27 (net019, net018);
rpp1k1 #(.l(2.3e-05), .w(2e-06), .m(1), .par1(1))
(* integer passed_mfactor = "m"; *)
 R26 (VOUT, net019);
rpp1k1 #(.l(2.3e-05), .w(2e-06), .m(1), .par1(1))
(* integer passed_mfactor = "m"; *)
 R25 (net020, VOUT);
rpp1k1 #(.l(2.3e-05), .w(2e-06), .m(1), .par1(1))
(* integer passed_mfactor = "m"; *)
 R24 (net021, net020);
rpp1k1 #(.l(2.3e-05), .w(2e-06), .m(1), .par1(1))
(* integer passed_mfactor = "m"; *)
 R23 (net022, net021);
rpp1k1 #(.l(2.3e-05), .w(2e-06), .m(1), .par1(1))
(* integer passed_mfactor = "m"; *)
 R22 (net023, net022);
rpp1k1 #(.l(2.3e-05), .w(2e-06), .m(1), .par1(1))
(* integer passed_mfactor = "m"; *)
 R21 (net024, net023);
rpp1k1 #(.l(2.3e-05), .w(2e-06), .m(1), .par1(1))
(* integer passed_mfactor = "m"; *)
 R20 (net025, net024);
rpp1k1 #(.l(2.3e-05), .w(2e-06), .m(1), .par1(1))
(* integer passed_mfactor = "m"; *)
 R19 (net026, net025);
rpp1k1 #(.l(2.3e-05), .w(2e-06), .m(1), .par1(1))
(* integer passed_mfactor = "m"; *)
 R18 (net027, net026);
rpp1k1 #(.l(2.3e-05), .w(2e-06), .m(1), .par1(1))
(* integer passed_mfactor = "m"; *)
 R17 (net028, net027);
rpp1k1 #(.l(2.3e-05), .w(2e-06), .m(1), .par1(1))
(* integer passed_mfactor = "m"; *)
 R16 (net029, net028);
rpp1k1 #(.l(2.3e-05), .w(2e-06), .m(1), .par1(1))
(* integer passed_mfactor = "m"; *)
 R15 (net030, net029);
rpp1k1 #(.l(2.3e-05), .w(2e-06), .m(1), .par1(1))
(* integer passed_mfactor = "m"; *)
 R14 (net031, net030);
rpp1k1 #(.l(2.3e-05), .w(2e-06), .m(1), .par1(1))
(* integer passed_mfactor = "m"; *)
 R13 (net032, net031);
rpp1k1 #(.l(2.3e-05), .w(2e-06), .m(1), .par1(1))
(* integer passed_mfactor = "m"; *)
 R12 (net033, net032);
rpp1k1 #(.l(2.3e-05), .w(2e-06), .m(1), .par1(1))
(* integer passed_mfactor = "m"; *)
 R11 (net034, net033);
rpp1k1 #(.l(2.3e-05), .w(2e-06), .m(1), .par1(1))
(* integer passed_mfactor = "m"; *)
 R10 (net035, net034);
rpp1k1 #(.l(2.3e-05), .w(2e-06), .m(1), .par1(1))
(* integer passed_mfactor = "m"; *)
 R9 (net036, net035);
rpp1k1 #(.l(2.3e-05), .w(2e-06), .m(1), .par1(1))
(* integer passed_mfactor = "m"; *)
 R8 (net037, net036);
rpp1k1 #(.l(2.3e-05), .w(2e-06), .m(1), .par1(1))
(* integer passed_mfactor = "m"; *)
 R7 (net038, net037);
rpp1k1 #(.l(2.3e-05), .w(2e-06), .m(1), .par1(1))
(* integer passed_mfactor = "m"; *)
 R6 (V1, net038);
rpp1k1 #(.l(2.3e-05), .w(2e-06), .m(1), .par1(1))
(* integer passed_mfactor = "m"; *)
 R5 (net08, net08);
rpp1k1 #(.l(2.3e-05), .w(2e-06), .m(1), .par1(1))
(* integer passed_mfactor = "m"; *)
 R4 (net07, net07);
rpp1k1 #(.l(2.3e-05), .w(2e-06), .m(1), .par1(1))
(* integer passed_mfactor = "m"; *)
 R3 (net5, net5);
rpp1k1 #(.l(2.3e-05), .w(2e-06), .m(1), .par1(1))
(* integer passed_mfactor = "m"; *)
 R2 (net6, net6);

endmodule
// Library - Stimulator_IMP, Cell - LS_HighSide_V3_ST, View - schematic
// LAST TIME SAVED: Apr  9 15:38:16 2021
// NETLIST TIME: Apr 30 15:39:15 2021

`worklib Stimulator_IMP
`view schematic

`timescale 1ns / 1ps
(* cds_ams_schematic *)

module LS_HighSide_V3_ST (out, .\gnd! (cdsNet2), .\vdd3! (cdsNet1), .\vdde! (cdsNet0), vddh, in);
output  out;
input  in;
inout  cdsNet2, cdsNet1, cdsNet0, vddh;
wire net10;
wire inn3v;
cds_alias #(1) cds_alias_inst1 ( cdsNet2 , cds_globals.\gnd! );
cds_alias #(1) cds_alias_inst2 ( cdsNet1 , cds_globals.\vdd3! );
cds_alias #(1) cds_alias_inst3 ( cdsNet0 , cds_globals.\vdde! );
ResistiveDivider I0 (.V2( net10 ), .V1( vddh ), .VOUT( out ));
LSHVT18U3VX1 I10 (.A( in ), .Q( inn3v ));
nedia_bjt #(.w(1.5e-05), .l(1.25e-06), .m((1)*(1)), .par1((1)*(1)), .extlay(0), .xf_subext(0))
(* integer passed_mfactor = "m"; *)
 M13 (net10, inn3v, cds_globals.\gnd! , cds_globals.\gnd! );

endmodule
// Library - Stimulator_IMP, Cell - LS_LowSide_V2_ST, View - schematic
// LAST TIME SAVED: Apr  9 15:57:59 2021
// NETLIST TIME: Apr 30 15:39:15 2021

`worklib Stimulator_IMP
`view schematic

`timescale 1ns / 1ps
(* cds_ams_schematic *)

module LS_LowSide_V2_ST (out, .\gnd! (cdsNet2), .\vdd3! (cdsNet1), .\vdde! (cdsNet0), vddh, in);
output  out;
input  in;
inout  cdsNet2, cdsNet1, cdsNet0, vddh;
wire net11;
wire net9;
cds_alias #(1) cds_alias_inst4 ( cdsNet2 , cds_globals.\gnd! );
cds_alias #(1) cds_alias_inst5 ( cdsNet1 , cds_globals.\vdd3! );
cds_alias #(1) cds_alias_inst6 ( cdsNet0 , cds_globals.\vdde! );
ResistiveDivider I2 (.V2(cds_globals.\gnd! ), .V1( net11 ), .VOUT( out ));
LS_HighSide_V3_ST I1 (.\vdde! (cds_globals.\vdde! ), .\gnd! (cds_globals.\gnd! ), .\vdd3! (cds_globals.\vdd3! ), .vddh( vddh ), .out( net9 ), .in( in ));
ped_bjt #(.w(2e-05), .l(9.4e-07), .m((1)*(1)), .par1((1)*(1)), .extlay(0), .xf_subext(0))
(* integer passed_mfactor = "m"; *)
 M1 (net11, net9, vddh, cds_globals.\gnd! );

endmodule
// Library - GATES_3V, Cell - invrv3, View - schematic
// LAST TIME SAVED: Mar  7 12:42:39 2018
// NETLIST TIME: Apr 30 15:39:15 2021

`worklib GATES_3V
`view schematic

`timescale 1ns / 1ps
(* cds_ams_schematic *)

module invrv3 (out, in);
output  out;
input  in;
wire (*
integer inh_conn_prop_name = "power_vdd3";
integer inh_conn_def_value = "cds_globals.\\vdd3! "; *)
\vdd3! ;
wire (*
integer inh_conn_prop_name = "ground_gnd";
integer inh_conn_def_value = "cds_globals.\\gnd! "; *)
\gnd! ;
parameter GT_PDW=0 ;
parameter GT_PDL=3.5e-07 ;
parameter sx=4.8e-07 ;
parameter lc=2.7e-07 ;
parameter GT_PUW=0 ;
parameter GT_PUL=3e-07 ;
ne3 #(.w(GT_PDW), .l(GT_PDL), .as(sx*(GT_PDW)), .ad(sx*(GT_PDW)), .ps(2*sx+(GT_PDW)), .pd(2*sx+(GT_PDW)), .nrs(lc/(GT_PDW)), .nrd(lc/(GT_PDW)), .m((1)*(1)), .par1((1)*(1)), .xf_subext(0))
(* integer passed_mfactor = "m"; *)
 MN1 (out, in, \gnd! , \gnd! );
pe3 #(.w(GT_PUW), .l(GT_PUL), .as(sx*(GT_PUW)), .ad(sx*(GT_PUW)), .ps(2*sx+(GT_PUW)), .pd(2*sx+(GT_PUW)), .nrs(lc/(GT_PUW)), .nrd(lc/(GT_PUW)), .m((1)*(1)), .par1((1)*(1)))
(* integer passed_mfactor = "m"; *)
 MP1 (out, in, \vdd3! , \vdd3! );

endmodule
// Library - D_CELLS_HD, Cell - AND2HDX0, View - cmos_sch
// LAST TIME SAVED: Jan 23 08:10:19 2018
// NETLIST TIME: Apr 30 15:39:15 2021

`worklib D_CELLS_HD
`view cmos_sch

`timescale 1ns / 1ps
(* cds_ams_schematic *)

module AND2HDX0 (Q, A, B);
output  Q;
input  A, B;
wire (*
integer inh_conn_prop_name = "ground_gnd";
integer inh_conn_def_value = "cds_globals.\\gnd! "; *)
\gnd! ;
wire (*
integer inh_conn_prop_name = "power_vdd";
integer inh_conn_def_value = "cds_globals.\\vdd! "; *)
\vdd! ;
wire net10;
nand2 #(.sx(4.8e-07), .GT_PUW(7.2e-07), .GT_PDL(1.8e-07), .lc(2.7e-07), .GT_PUL(1.8e-07), .GT_PDW(4.2e-07)) nand2_1 (.a( A ), .b( B ), .out( net10 ));
invr #(.sx(4.8e-07), .GT_PUW(7.2e-07), .GT_PDL(1.8e-07), .lc(2.7e-07), .GT_PUL(1.8e-07), .GT_PDW(4.2e-07)) invr_1 (.out( Q ), .in( net10 ));

endmodule
// Library - D_CELLS_3V, Cell - IN_3VX2, View - cmos_sch
// LAST TIME SAVED: Feb 20 10:23:55 2018
// NETLIST TIME: Apr 30 15:39:15 2021

`worklib D_CELLS_3V
`view cmos_sch

`timescale 1ns / 1ps
(* cds_ams_schematic *)

module IN_3VX2 (Q, A);
output  Q;
input  A;
wire (*
integer inh_conn_prop_name = "power_vdd3";
integer inh_conn_def_value = "cds_globals.\\vdd3! "; *)
\vdd3! ;
wire (*
integer inh_conn_prop_name = "ground_gnd";
integer inh_conn_def_value = "cds_globals.\\gnd! "; *)
\gnd! ;
invrv3 #(.sx(4.8e-07), .GT_PUW(2.94e-06), .GT_PDL(3.5e-07), .lc(2.7e-07), .GT_PUL(3e-07), .GT_PDW(9.6e-07)) invr_1 (.in( A ), .out( Q ));

endmodule
// Library - Stimulator_TestBench, Cell - TB_OneChannel_imp, View - schematic
// LAST TIME SAVED: Apr 30 15:38:39 2021
// NETLIST TIME: Apr 30 15:39:15 2021

`worklib Stimulator_TestBench
`view schematic

`timescale 1ns / 1ps
(* cds_ams_schematic *)

module TB_OneChannel_imp ( );
wire [4:0] MAG_ST;
wire EN_ST;
wire DIS_ST;
wire CAT_ST;
wire ANO_ST;
wire D0_3v;
wire net247;
wire D1_3v;
wire net253;
wire D2_3v;
wire net254;
wire D3_3v;
wire net255;
wire D4_3v;
wire net257;
wire net238;
wire net233;
wire en_3v;
wire net071;
wire net070;
wire net069;
wire net068;
wire net067;
wire Ctrl_LS;
wire vddh;
wire Ctrl_HS;
Digital_Stimulus_ST #(.InterPulseDelay(30), .ANO_phase(100), .CAT_phase(100), .Ramping(1'b1)) I38 (.ANO_ST( ANO_ST ), .CAT_ST( CAT_ST ), .DIS_ST( DIS_ST ), .EN_ST( EN_ST ), .MAG_ST( MAG_ST ));
IN_3VX2 I31 (.A( net247 ), .Q( D0_3v ));
IN_3VX2 I3 (.A( net253 ), .Q( D1_3v ));
IN_3VX2 I5 (.A( net254 ), .Q( D2_3v ));
IN_3VX2 I7 (.A( net255 ), .Q( D3_3v ));
IN_3VX2 I9 (.A( net257 ), .Q( D4_3v ));
LSHVT18U3VX1 I34 (.A( ANO_ST ), .Q( net238 ));
LSHVT18U3VX1 I27 (.A( ANO_ST ), .Q( net233 ));
LSHVT18U3VX1 I17 (.A( EN_ST ), .Q( en_3v ));
LSHVT18U3VX1 I0 (.A( net071 ), .Q( net247 ));
LSHVT18U3VX1 I30 (.A( net070 ), .Q( net253 ));
LSHVT18U3VX1 I4 (.A( net069 ), .Q( net254 ));
LSHVT18U3VX1 I6 (.A( net068 ), .Q( net255 ));
LSHVT18U3VX1 I29 (.A( net067 ), .Q( net257 ));
LS_LowSide_V2_ST I33 (.\gnd! (cds_globals.\gnd! ), .\vdd3! (cds_globals.\vdd3! ), .\vdde! (cds_globals.\vdde! ), .vddh( vddh ), .out( Ctrl_LS ), .in( CAT_ST ));
LS_HighSide_V3_ST I36 (.\vdde! (cds_globals.\vdde! ), .\gnd! (cds_globals.\gnd! ), .\vdd3! (cds_globals.\vdd3! ), .vddh( vddh ), .out( Ctrl_HS ), .in( CAT_ST ));
AND2HDX0 I49 (.Q( net067 ), .B( MAG_ST[4] ), .A( EN_ST ));
AND2HDX0 I48 (.Q( net068 ), .B( MAG_ST[3] ), .A( EN_ST ));
AND2HDX0 I47 (.Q( net069 ), .B( MAG_ST[2] ), .A( EN_ST ));
AND2HDX0 I46 (.Q( net070 ), .B( MAG_ST[1] ), .A( EN_ST ));
AND2HDX0 I45 (.Q( net071 ), .B( MAG_ST[0] ), .A( EN_ST ));
nedia_bjt #(.w(3e-05), .l(1.25e-06), .m((1)*(1)), .par1((1)*(1)), .extlay(0), .xf_subext(0))
(* integer passed_mfactor = "m"; *)
 M20 (net237, net238, cds_globals.\gnd! , cds_globals.\gnd! );
nedia_bjt #(.w(3e-05), .l(1.25e-06), .m((1)*(1)), .par1((1)*(1)), .extlay(0), .xf_subext(0))
(* integer passed_mfactor = "m"; *)
 M19 (net235, net233, cds_globals.\gnd! , cds_globals.\gnd! );
nedia_bjt #(.w(0.0001), .l(1.25e-06), .m((1)*(6)), .par1((1)*(6)), .extlay(0), .xf_subext(0))
(* integer passed_mfactor = "m"; *)
 M2 (net207, net231, net206, cds_globals.\gnd! );
nedia_bjt #(.w(0.0001), .l(1.25e-06), .m((1)*(6)), .par1((1)*(6)), .extlay(0), .xf_subext(0))
(* integer passed_mfactor = "m"; *)
 M1 (net205, Ctrl_LS, net206, cds_globals.\gnd! );
nedia_bjt #(.w(6e-05), .l(1.25e-06), .m((1)*(1)), .par1((1)*(1)), .extlay(0), .xf_subext(0))
(* integer passed_mfactor = "m"; *)
 M4 (net256, net201, cds_globals.\gnd! , cds_globals.\gnd! );
nedia_bjt #(.w(6e-05), .l(1.25e-06), .m((10)*(1)), .par1((10)*(1)), .extlay(0), .xf_subext(0))
(* integer passed_mfactor = "m"; *)
 M6 (net197, net197, cds_globals.\gnd! , cds_globals.\gnd! );
nedia_bjt #(.w(2e-05), .l(1.25e-06), .m((1)*(1)), .par1((1)*(1)), .extlay(0), .xf_subext(0))
(* integer passed_mfactor = "m"; *)
 M7 (VB, net198, net197, cds_globals.\gnd! );
nedia_bjt #(.w(6e-05), .l(1.25e-06), .m((1)*(1)), .par1((1)*(1)), .extlay(0), .xf_subext(0))
(* integer passed_mfactor = "m"; *)
 M5 (net201, VB, net256, cds_globals.\gnd! );
nedia_bjt #(.w(6e-05), .l(1.25e-06), .m((10)*(1)), .par1((10)*(1)), .extlay(0), .xf_subext(0))
(* integer passed_mfactor = "m"; *)
 M8 (net198, net198, VB, cds_globals.\gnd! );
nedia_bjt #(.w(3e-05), .l(1.25e-06), .m((1)*(1)), .par1((1)*(1)), .extlay(0), .xf_subext(0))
(* integer passed_mfactor = "m"; *)
 M21 (net202, net202, net201, cds_globals.\gnd! );
nedia_bjt #(.w(5e-05), .l(1.25e-06), .m((1)*(5)), .par1((1)*(5)), .extlay(0), .xf_subext(0))
(* integer passed_mfactor = "m"; *)
 M16 (Bias2, en_3v, net090, cds_globals.\gnd! );
nedia_bjt #(.w(1e-05), .l(1.25e-06), .m((1)*(1)), .par1((1)*(1)), .extlay(0), .xf_subext(0))
(* integer passed_mfactor = "m"; *)
 M9 (net195, cds_globals.\vdd3! , cds_globals.\gnd! , cds_globals.\gnd! );
nedia_bjt #(.w(1e-05), .l(1.25e-06), .m((1)*(1)), .par1((1)*(1)), .extlay(0), .xf_subext(0))
(* integer passed_mfactor = "m"; *)
 M10 (net090, net195, cds_globals.\gnd! , cds_globals.\gnd! );
nedia_bjt #(.w(6e-05), .l(1.25e-06), .m((10)*(1)), .par1((10)*(1)), .extlay(0), .xf_subext(0))
(* integer passed_mfactor = "m"; *)
 M0 (net206, VB, net258, cds_globals.\gnd! );
nedia_bjt #(.w(6e-05), .l(1.25e-06), .m((10)*(1)), .par1((10)*(1)), .extlay(0), .xf_subext(0))
(* integer passed_mfactor = "m"; *)
 M3 (net258, net201, cds_globals.\gnd! , cds_globals.\gnd! );
ped_bjt #(.w(0.0001), .l(9.4e-07), .m((1)*(6)), .par1((1)*(6)), .extlay(0), .xf_subext(0))
(* integer passed_mfactor = "m"; *)
 M25 (net207, Ctrl_HS, vddh, cds_globals.\gnd! );
ped_bjt #(.w(0.0001), .l(9.4e-07), .m((1)*(6)), .par1((1)*(6)), .extlay(0), .xf_subext(0))
(* integer passed_mfactor = "m"; *)
 M24 (net205, net204, vddh, cds_globals.\gnd! );
ped_bjt #(.w(3e-05), .l(9.4e-07), .m((1)*(1)), .par1((1)*(1)), .extlay(0), .xf_subext(0))
(* integer passed_mfactor = "m"; *)
 M23 (net236, net232, vddh, cds_globals.\gnd! );
ped_bjt #(.w(3e-05), .l(9.4e-07), .m((1)*(1)), .par1((1)*(1)), .extlay(0), .xf_subext(0))
(* integer passed_mfactor = "m"; *)
 M12 (net202, Bias2, net239, cds_globals.\gnd! );
ped_bjt #(.w(3e-05), .l(9.4e-07), .m((1)*(1)), .par1((1)*(1)), .extlay(0), .xf_subext(0))
(* integer passed_mfactor = "m"; *)
 M11 (net239, net194, vddh, cds_globals.\gnd! );
ped_bjt #(.w(3e-05), .l(9.4e-07), .m((1)*(1)), .par1((1)*(1)), .extlay(0), .xf_subext(0))
(* integer passed_mfactor = "m"; *)
 M15 (net240, net194, vddh, cds_globals.\gnd! );
ped_bjt #(.w(3e-05), .l(9.4e-07), .m((1)*(1)), .par1((1)*(1)), .extlay(0), .xf_subext(0))
(* integer passed_mfactor = "m"; *)
 M18 (Bias2, Bias2, net194, cds_globals.\gnd! );
ped_bjt #(.w(3e-05), .l(9.4e-07), .m((1)*(1)), .par1((1)*(1)), .extlay(0), .xf_subext(0))
(* integer passed_mfactor = "m"; *)
 M17 (net194, net194, vddh, cds_globals.\gnd! );
ped_bjt #(.w(3e-05), .l(9.4e-07), .m((1)*(1)), .par1((1)*(1)), .extlay(0), .xf_subext(0))
(* integer passed_mfactor = "m"; *)
 M14 (net198, Bias2, net240, cds_globals.\gnd! );
csft5a #(.area(6.3936e-11), .perimeter(3.372e-05), .m(45), .par1(45))
(* integer passed_mfactor = "m"; *)
 C1 (net195, cds_globals.\gnd! );
csft5a #(.area(6.3936e-11), .perimeter(3.372e-05), .m(15), .par1(15))
(* integer passed_mfactor = "m"; *)
 C5 (vddh, net195);
ne3 #(.w(4e-05), .l(2e-06), .as(1.92e-11), .ad(1.92e-11), .ps(8.096e-05), .pd(8.096e-05), .nrs(0.00675), .nrd(0.00675), .m((1)*(1)), .par1((1)*(1)), .xf_subext(0))
(* integer passed_mfactor = "m"; *)
 M26 (net181, net181, cds_globals.\gnd! , cds_globals.\gnd! );
ne3 #(.w(2e-05), .l(1e-06), .as(9.6e-12), .ad(9.6e-12), .ps(4.096e-05), .pd(4.096e-05), .nrs(0.0135), .nrd(0.0135), .m((1)*(1)), .par1((1)*(1)), .xf_subext(0))
(* integer passed_mfactor = "m"; *)
 M56 (VBp2, net025, net076, cds_globals.\gnd! );
ne3 #(.w(2e-05), .l(1e-06), .as(9.6e-12), .ad(9.6e-12), .ps(4.096e-05), .pd(4.096e-05), .nrs(0.0135), .nrd(0.0135), .m((1)*(1)), .par1((1)*(1)), .xf_subext(0))
(* integer passed_mfactor = "m"; *)
 M34 (net025, net025, net024, cds_globals.\gnd! );
ne3 #(.w(2e-05), .l(1e-06), .as(9.6e-12), .ad(9.6e-12), .ps(4.096e-05), .pd(4.096e-05), .nrs(0.0135), .nrd(0.0135), .m((1)*(1)), .par1((1)*(1)), .xf_subext(0))
(* integer passed_mfactor = "m"; *)
 M30 (net024, net024, cds_globals.\gnd! , cds_globals.\gnd! );
ne3 #(.w(2e-05), .l(1e-06), .as(9.6e-12), .ad(9.6e-12), .ps(4.096e-05), .pd(4.096e-05), .nrs(0.0135), .nrd(0.0135), .m((1)*(1)), .par1((1)*(1)), .xf_subext(0))
(* integer passed_mfactor = "m"; *)
 M27 (net076, net024, cds_globals.\gnd! , cds_globals.\gnd! );
ne3 #(.w(4e-05), .l(2e-06), .as(1.248e-11), .ad(1.08e-11), .ps(4.8624e-05), .pd(4.054e-05), .nrs(0.00675), .nrd(0.00675), .m((1)*(10)), .par1((1)*(10)), .xf_subext(0))
(* integer passed_mfactor = "m"; *)
 M13 (net090, net181, cds_globals.\gnd! , cds_globals.\gnd! );
pe3 #(.w(1e-05), .l(1e-06), .as(2.9625e-12), .ad(2.7e-12), .ps(1.18425e-05), .pd(1.054e-05), .nrs(0.027), .nrd(0.027), .m((1)*(16)), .par1((1)*(16)))
(* integer passed_mfactor = "m"; *)
 M41 (net241, net178, cds_globals.\vdd3! , cds_globals.\vdd3! );
pe3 #(.w(1e-05), .l(1e-06), .as(3.225e-12), .ad(2.7e-12), .ps(1.3145e-05), .pd(1.054e-05), .nrs(0.027), .nrd(0.027), .m((1)*(8)), .par1((1)*(8)))
(* integer passed_mfactor = "m"; *)
 M38 (net242, net178, cds_globals.\vdd3! , cds_globals.\vdd3! );
pe3 #(.w(1e-05), .l(1e-06), .as(3.75e-12), .ad(2.7e-12), .ps(1.575e-05), .pd(1.054e-05), .nrs(0.027), .nrd(0.027), .m((1)*(4)), .par1((1)*(4)))
(* integer passed_mfactor = "m"; *)
 M35 (net243, net178, cds_globals.\vdd3! , cds_globals.\vdd3! );
pe3 #(.w(1e-05), .l(1e-06), .as(4.8e-12), .ad(2.7e-12), .ps(2.096e-05), .pd(1.054e-05), .nrs(0.027), .nrd(0.027), .m((1)*(2)), .par1((1)*(2)))
(* integer passed_mfactor = "m"; *)
 M32 (net244, net178, cds_globals.\vdd3! , cds_globals.\vdd3! );
pe3 #(.w(1e-05), .l(1e-06), .as(4.8e-12), .ad(4.8e-12), .ps(2.096e-05), .pd(2.096e-05), .nrs(0.027), .nrd(0.027), .m((1)*(1)), .par1((1)*(1)))
(* integer passed_mfactor = "m"; *)
 M22 (net245, net178, cds_globals.\vdd3! , cds_globals.\vdd3! );
pe3 #(.w(1e-05), .l(1e-06), .as(2.9625e-12), .ad(2.7e-12), .ps(1.18425e-05), .pd(1.054e-05), .nrs(0.027), .nrd(0.027), .m((1)*(16)), .par1((1)*(16)))
(* integer passed_mfactor = "m"; *)
 M42 (net248, VBp2, net241, cds_globals.\vdd3! );
pe3 #(.w(1e-05), .l(1e-06), .as(3.225e-12), .ad(2.7e-12), .ps(1.3145e-05), .pd(1.054e-05), .nrs(0.027), .nrd(0.027), .m((1)*(8)), .par1((1)*(8)))
(* integer passed_mfactor = "m"; *)
 M39 (net249, VBp2, net242, cds_globals.\vdd3! );
pe3 #(.w(1e-05), .l(1e-06), .as(3.75e-12), .ad(2.7e-12), .ps(1.575e-05), .pd(1.054e-05), .nrs(0.027), .nrd(0.027), .m((1)*(4)), .par1((1)*(4)))
(* integer passed_mfactor = "m"; *)
 M36 (net250, VBp2, net243, cds_globals.\vdd3! );
pe3 #(.w(1e-05), .l(1e-06), .as(4.8e-12), .ad(2.7e-12), .ps(2.096e-05), .pd(1.054e-05), .nrs(0.027), .nrd(0.027), .m((1)*(2)), .par1((1)*(2)))
(* integer passed_mfactor = "m"; *)
 M33 (net251, VBp2, net244, cds_globals.\vdd3! );
pe3 #(.w(1e-05), .l(1e-06), .as(4.8e-12), .ad(4.8e-12), .ps(2.096e-05), .pd(2.096e-05), .nrs(0.027), .nrd(0.027), .m((1)*(1)), .par1((1)*(1)))
(* integer passed_mfactor = "m"; *)
 M29 (net252, VBp2, net245, cds_globals.\vdd3! );
pe3 #(.w(1e-05), .l(3e-07), .as(4.8e-12), .ad(4.8e-12), .ps(2.096e-05), .pd(2.096e-05), .nrs(0.027), .nrd(0.027), .m((1)*(1)), .par1((1)*(1)))
(* integer passed_mfactor = "m"; *)
 M44 (net181, D1_3v, net251, cds_globals.\vdd3! );
pe3 #(.w(1e-05), .l(3e-07), .as(4.8e-12), .ad(4.8e-12), .ps(2.096e-05), .pd(2.096e-05), .nrs(0.027), .nrd(0.027), .m((1)*(1)), .par1((1)*(1)))
(* integer passed_mfactor = "m"; *)
 M45 (net181, D2_3v, net250, cds_globals.\vdd3! );
pe3 #(.w(1e-05), .l(3e-07), .as(4.8e-12), .ad(4.8e-12), .ps(2.096e-05), .pd(2.096e-05), .nrs(0.027), .nrd(0.027), .m((1)*(1)), .par1((1)*(1)))
(* integer passed_mfactor = "m"; *)
 M46 (net181, D3_3v, net249, cds_globals.\vdd3! );
pe3 #(.w(1e-05), .l(3e-07), .as(4.8e-12), .ad(4.8e-12), .ps(2.096e-05), .pd(2.096e-05), .nrs(0.027), .nrd(0.027), .m((1)*(1)), .par1((1)*(1)))
(* integer passed_mfactor = "m"; *)
 M47 (net181, D4_3v, net248, cds_globals.\vdd3! );
pe3 #(.w(1e-05), .l(3e-07), .as(4.8e-12), .ad(4.8e-12), .ps(2.096e-05), .pd(2.096e-05), .nrs(0.027), .nrd(0.027), .m((1)*(1)), .par1((1)*(1)))
(* integer passed_mfactor = "m"; *)
 M31 (net181, D0_3v, net252, cds_globals.\vdd3! );
pe3 #(.w(1e-05), .l(1e-06), .as(4.8e-12), .ad(4.8e-12), .ps(2.096e-05), .pd(2.096e-05), .nrs(0.027), .nrd(0.027), .m((1)*(1)), .par1((1)*(1)))
(* integer passed_mfactor = "m"; *)
 M55 (VBp2, VBp2, net178, cds_globals.\vdd3! );
pe3 #(.w(1e-05), .l(1e-06), .as(4.8e-12), .ad(4.8e-12), .ps(2.096e-05), .pd(2.096e-05), .nrs(0.027), .nrd(0.027), .m((1)*(1)), .par1((1)*(1)))
(* integer passed_mfactor = "m"; *)
 M52 (net178, net178, cds_globals.\vdd3! , cds_globals.\vdd3! );
vsource #(.dc(1.8), .type("dc")) V1 (cds_globals.\vdd! , cds_globals.\gnd! );
vsource #(.dc(40), .type("dc")) V0 (vddh, cds_globals.\gnd! );
vsource #(.dc(1.8), .type("dc")) V4 (cds_globals.\vdde! , cds_globals.\gnd! );
vsource #(.dc(3.3), .type("dc")) V3 (cds_globals.\vdd3! , cds_globals.\gnd! );
isource #(.dc(1e-05), .type("dc")) I35 (cds_globals.\vdd3! , net077);
rpp1k1 #(.l(0.00030447), .w(2e-06), .m(1), .par1(1))
(* integer passed_mfactor = "m"; *)
 R2 (vddh, net204);
rpp1k1 #(.l(0.00030447), .w(2e-06), .m(1), .par1(1))
(* integer passed_mfactor = "m"; *)
 R17 (vddh, net232);
rpp1k1 #(.l(0.000507595), .w(2e-06), .m(1), .par1(1))
(* integer passed_mfactor = "m"; *)
 R8 (net204, net237);
rpp1k1 #(.l(0.000507595), .w(2e-06), .m(1), .par1(1))
(* integer passed_mfactor = "m"; *)
 R16 (net236, net231);
rpp1k1 #(.l(0.000507595), .w(2e-06), .m(1), .par1(1))
(* integer passed_mfactor = "m"; *)
 R18 (net232, net235);
rpp1k1 #(.l(0.00030447), .w(2e-06), .m(1), .par1(1))
(* integer passed_mfactor = "m"; *)
 R9 (net231, cds_globals.\gnd! );
rpp1k1 #(.l(2.0095e-05), .w(2e-06), .m(1), .par1(1))
(* integer passed_mfactor = "m"; *)
 R3 (net077, net025);
resistor #(.r(1000)) R0 (net205, net207);
vsource #(.type("pwl"), .wave({"0", "0", "5e-05", "0", "5.1e-05", "40"})) V12 (net060, cds_globals.\gnd! );

endmodule
// Library - D_CELLS_M3V, Cell - LSHVT18U3VX1, View - cmos_sch
// LAST TIME SAVED: Jun  7 14:44:58 2018
// NETLIST TIME: Apr 30 15:39:15 2021

`worklib D_CELLS_M3V
`view cmos_sch

`timescale 1ns / 1ps
(* cds_ams_schematic *)

module LSHVT18U3VX1 (Q, A);
output  Q;
input  A;
wire (*
integer inh_conn_prop_name = "power_vdd3";
integer inh_conn_def_value = "cds_globals.\\vdd3! "; *)
\vdd3! ;
wire (*
integer inh_conn_prop_name = "ground_gnd";
integer inh_conn_def_value = "cds_globals.\\gnd! "; *)
\gnd! ;
wire (*
integer inh_conn_prop_name = "power_vdde";
integer inh_conn_def_value = "cds_globals.\\vdde! "; *)
\vdde! ;
pe3 #(.w(1.46e-06), .l(3e-07), .as(7.008e-13), .ad(7.008e-13), .ps(3.88e-06), .pd(3.88e-06), .nrs(0.184932), .nrd(0.184932), .m((1)*(1)), .par1((1)*(1)))
(* integer passed_mfactor = "m"; *)
 M6 (Q, net20, \vdd3! , \vdd3! );
pe3 #(.w(1.48e-06), .l(3e-07), .as(7.104e-13), .ad(7.104e-13), .ps(3.92e-06), .pd(3.92e-06), .nrs(0.182432), .nrd(0.182432), .m((1)*(1)), .par1((1)*(1)))
(* integer passed_mfactor = "m"; *)
 M8 (net4, A, \vdde! , \vdd3! );
pe3 #(.w(4.2e-07), .l(3e-07), .as(2.016e-13), .ad(2.016e-13), .ps(1.8e-06), .pd(1.8e-06), .nrs(0.642857), .nrd(0.642857), .m((1)*(1)), .par1((1)*(1)))
(* integer passed_mfactor = "m"; *)
 M9 (net20, A, net024, \vdd3! );
pe3 #(.w(4.2e-07), .l(3e-07), .as(2.016e-13), .ad(2.016e-13), .ps(1.8e-06), .pd(1.8e-06), .nrs(0.642857), .nrd(0.642857), .m((1)*(1)), .par1((1)*(1)))
(* integer passed_mfactor = "m"; *)
 M0 (net10, net4, net023, \vdd3! );
pe3 #(.w(4.2e-07), .l(3e-07), .as(2.016e-13), .ad(2.016e-13), .ps(1.8e-06), .pd(1.8e-06), .nrs(0.642857), .nrd(0.642857), .m((1)*(1)), .par1((1)*(1)))
(* integer passed_mfactor = "m"; *)
 M2 (net023, net20, \vdd3! , \vdd3! );
pe3 #(.w(4.2e-07), .l(3e-07), .as(2.016e-13), .ad(2.016e-13), .ps(1.8e-06), .pd(1.8e-06), .nrs(0.642857), .nrd(0.642857), .m((1)*(1)), .par1((1)*(1)))
(* integer passed_mfactor = "m"; *)
 M4 (net024, net10, \vdd3! , \vdd3! );
ne3 #(.w(1.31e-06), .l(3.5e-07), .as(6.288e-13), .ad(6.288e-13), .ps(3.58e-06), .pd(3.58e-06), .nrs(0.206107), .nrd(0.206107), .m((1)*(1)), .par1((1)*(1)), .xf_subext(0))
(* integer passed_mfactor = "m"; *)
 M3 (net20, A, \gnd! , \gnd! );
ne3 #(.w(8.9e-07), .l(3.5e-07), .as(4.272e-13), .ad(4.272e-13), .ps(2.74e-06), .pd(2.74e-06), .nrs(0.303371), .nrd(0.303371), .m((1)*(1)), .par1((1)*(1)), .xf_subext(0))
(* integer passed_mfactor = "m"; *)
 M5 (Q, net20, \gnd! , \gnd! );
ne3 #(.w(4.2e-07), .l(3.5e-07), .as(2.016e-13), .ad(2.016e-13), .ps(1.8e-06), .pd(1.8e-06), .nrs(0.642857), .nrd(0.642857), .m((1)*(1)), .par1((1)*(1)), .xf_subext(0))
(* integer passed_mfactor = "m"; *)
 M7 (net4, A, \gnd! , \gnd! );
ne3 #(.w(1.31e-06), .l(3.5e-07), .as(6.288e-13), .ad(6.288e-13), .ps(3.58e-06), .pd(3.58e-06), .nrs(0.206107), .nrd(0.206107), .m((1)*(1)), .par1((1)*(1)), .xf_subext(0))
(* integer passed_mfactor = "m"; *)
 M1 (net10, net4, \gnd! , \gnd! );

endmodule
// Library - GATES_HD, Cell - nand2, View - schematic
// LAST TIME SAVED: Jan 18 15:00:04 2018
// NETLIST TIME: Apr 30 15:39:15 2021

`worklib GATES_HD
`view schematic

`timescale 1ns / 1ps
(* cds_ams_schematic *)

module nand2 (out, a, b);
output  out;
input  a, b;
wire (*
integer inh_conn_prop_name = "ground_gnd";
integer inh_conn_def_value = "cds_globals.\\gnd! "; *)
\gnd! ;
wire (*
integer inh_conn_prop_name = "power_vdd";
integer inh_conn_def_value = "cds_globals.\\vdd! "; *)
\vdd! ;
parameter GT_PDW=0 ;
parameter GT_PDL=1.8e-07 ;
parameter sx=4.8e-07 ;
parameter lc=2.7e-07 ;
parameter GT_PUW=0 ;
parameter GT_PUL=1.8e-07 ;
ne #(.w(GT_PDW), .l(GT_PDL), .as(sx*(GT_PDW)), .ad(sx*(GT_PDW)), .ps(2*(sx+(GT_PDW))), .pd(2*(sx+(GT_PDW))), .nrs(lc/(GT_PDW)), .nrd(lc/(GT_PDW)), .m((1)*(1)), .par1((1)*(1)), .xf_subext(0))
(* integer passed_mfactor = "m"; *)
 MN1 (out, a, net11, \gnd! );
ne #(.w(GT_PDW), .l(GT_PDL), .as(sx*(GT_PDW)), .ad(sx*(GT_PDW)), .ps(2*(sx+(GT_PDW))), .pd(2*(sx+(GT_PDW))), .nrs(lc/(GT_PDW)), .nrd(lc/(GT_PDW)), .m((1)*(1)), .par1((1)*(1)), .xf_subext(0))
(* integer passed_mfactor = "m"; *)
 MN2 (net11, b, \gnd! , \gnd! );
pe #(.w(GT_PUW), .l(GT_PUL), .as(sx*(GT_PUW)), .ad(sx*(GT_PUW)), .ps(2*(sx+(GT_PUW))), .pd(2*(sx+(GT_PUW))), .nrs(lc/(GT_PUW)), .nrd(lc/(GT_PUW)), .m((1)*(1)), .par1((1)*(1)))
(* integer passed_mfactor = "m"; *)
 MP1 (out, a, \vdd! , \vdd! );
pe #(.w(GT_PUW), .l(GT_PUL), .as(sx*(GT_PUW)), .ad(sx*(GT_PUW)), .ps(2*(sx+(GT_PUW))), .pd(2*(sx+(GT_PUW))), .nrs(lc/(GT_PUW)), .nrd(lc/(GT_PUW)), .m((1)*(1)), .par1((1)*(1)))
(* integer passed_mfactor = "m"; *)
 MP2 (out, b, \vdd! , \vdd! );

endmodule
// Library - GATES_HD, Cell - invr, View - schematic
// LAST TIME SAVED: Jan 18 15:00:13 2018
// NETLIST TIME: Apr 30 15:39:15 2021

`worklib GATES_HD
`view schematic

`timescale 1ns / 1ps
(* cds_ams_schematic *)

module invr (out, in);
output  out;
input  in;
wire (*
integer inh_conn_prop_name = "ground_gnd";
integer inh_conn_def_value = "cds_globals.\\gnd! "; *)
\gnd! ;
wire (*
integer inh_conn_prop_name = "power_vdd";
integer inh_conn_def_value = "cds_globals.\\vdd! "; *)
\vdd! ;
parameter GT_PDW=0 ;
parameter GT_PDL=1.8e-07 ;
parameter sx=4.8e-07 ;
parameter lc=2.7e-07 ;
parameter GT_PUW=0 ;
parameter GT_PUL=1.8e-07 ;
ne #(.w(GT_PDW), .l(GT_PDL), .as(sx*(GT_PDW)), .ad(sx*(GT_PDW)), .ps(2*(sx+(GT_PDW))), .pd(2*(sx+(GT_PDW))), .nrs(lc/(GT_PDW)), .nrd(lc/(GT_PDW)), .m((1)*(1)), .par1((1)*(1)), .xf_subext(0))
(* integer passed_mfactor = "m"; *)
 ne (out, in, \gnd! , \gnd! );
pe #(.w(GT_PUW), .l(GT_PUL), .as(sx*(GT_PUW)), .ad(sx*(GT_PUW)), .ps(2*(sx+(GT_PUW))), .pd(2*(sx+(GT_PUW))), .nrs(lc/(GT_PUW)), .nrd(lc/(GT_PUW)), .m((1)*(1)), .par1((1)*(1)))
(* integer passed_mfactor = "m"; *)
 pe (out, in, \vdd! , \vdd! );

endmodule
`noworklib
`noview
