// Design: Stimulator_TestBench/TB_OneChannel_imp
simulator lang=spectre
global 0 vdd3! vdde!
parameters D0=1.8 D1=0 D2=0 D3=0 D4=0
include "/pkg/xfab/XKIT/xh018/cadence/v8_0/spectre/v8_0_1/lpmos/config.scs" section=default
include "/pkg/xfab/XKIT/xh018/cadence/v8_0/spectre/v8_0_1/lpmos/param.scs" section=3s
include "/pkg/xfab/XKIT/xh018/cadence/v8_0/spectre/v8_0_1/lpmos/bip.scs" section=tm
include "/pkg/xfab/XKIT/xh018/cadence/v8_0/spectre/v8_0_1/lpmos/cap.scs" section=tm
include "/pkg/xfab/XKIT/xh018/cadence/v8_0/spectre/v8_0_1/lpmos/dio.scs" section=tm
include "/pkg/xfab/XKIT/xh018/cadence/v8_0/spectre/v8_0_1/lpmos/mos.scs" section=tm
include "/pkg/xfab/XKIT/xh018/cadence/v8_0/spectre/v8_0_1/lpmos/photo.scs" section=tm
include "/pkg/xfab/XKIT/xh018/cadence/v8_0/spectre/v8_0_1/lpmos/res.scs" section=tm

// GATES_3V/invrv3/schematic
subckt invrv3 in out inh_ground_gnd inh_power_vdd3
parameters GT_PDW GT_PDL=350.00n sx=4.8e-07 lc=2.7e-07 GT_PUW GT_PUL=300.00n
    MN1 (out in inh_ground_gnd inh_ground_gnd) ne3 w=GT_PDW l=GT_PDL m=(1)*(1)
    MP1 (out in inh_power_vdd3 inh_power_vdd3) pe3 w=GT_PUW l=GT_PUL m=(1)*(1)
ends invrv3

// D_CELLS_3V/IN_3VX2/cmos_sch
subckt IN_3VX2 A Q inh_ground_gnd inh_power_vdd3
    invr_1 (A Q inh_ground_gnd inh_power_vdd3) invrv3 GT_PDW=960.00n GT_PDL=350.00n sx=4.8e-07 lc=2.7e-07 GT_PUW=2.94u GT_PUL=300.00n
ends IN_3VX2

// D_CELLS_M3V/LSHVT18U3VX1/cmos_sch
subckt LSHVT18U3VX1 A Q inh_ground_gnd inh_power_vdd3 inh_power_vdde
    M6 (Q net20 inh_power_vdd3 inh_power_vdd3) pe3 w=1.46u l=300n m=(1)*(1)
    M8 (net4 A inh_power_vdde inh_power_vdd3) pe3 w=1.48u l=300n m=(1)*(1)
    M9 (net20 A net024 inh_power_vdd3) pe3 w=420.0n l=300n m=(1)*(1)
    M0 (net10 net4 net023 inh_power_vdd3) pe3 w=420.0n l=300n m=(1)*(1)
    M2 (net023 net20 inh_power_vdd3 inh_power_vdd3) pe3 w=420.0n l=300n m=(1)*(1)
    M4 (net024 net10 inh_power_vdd3 inh_power_vdd3) pe3 w=420.0n l=300n m=(1)*(1)
    M3 (net20 A inh_ground_gnd inh_ground_gnd) ne3 w=1.31u l=350.0n m=(1)*(1)
    M5 (Q net20 inh_ground_gnd inh_ground_gnd) ne3 w=890.0n l=350.0n m=(1)*(1)
    M7 (net4 A inh_ground_gnd inh_ground_gnd) ne3 w=420.0n l=350.0n m=(1)*(1)
    M1 (net10 net4 inh_ground_gnd inh_ground_gnd) ne3 w=1.31u l=350.0n m=(1)*(1)
ends LSHVT18U3VX1

// Stimulator_IMP/LS_LowSide_V2_ST/schematic
subckt LS_LowSide_V2_ST 0 in out vdd3! vdde! vddh inh_ground_gnd inh_power_vdd3 inh_power_vdde
    M0 (net12 in_3V 0 0) nedia_bjt w=30u l=1.25u m=(1)*(1) par1=((1)*(1)) extlay=0 xf_subext=0
    R2 (net9 net12) rpp1k1 l=507.595u w=2u m=1 par1=(1)
    R0 (out 0) rpp1k1 l=304.47u w=2u m=1 par1=(1)
    R1 (vddh net9) rpp1k1 l=304.47u w=2u m=1 par1=(1)
    R3 (net11 out) rpp1k1 l=507.595u w=2u m=1 par1=(1)
    M1 (net11 net9 vddh 0) ped_bjt w=30u l=940.0n m=(1)*(1) par1=((1)*(1)) extlay=0 xf_subext=0
    I0 (in in_3V inh_ground_gnd inh_power_vdd3 inh_power_vdde) LSHVT18U3VX1
ends LS_LowSide_V2_ST

// Stimulator_IMP/LS_HighSide_V3_ST/schematic
subckt LS_HighSide_V3_ST 0 in out vdd3! vdde! vddh inh_ground_gnd inh_power_vdd3 inh_power_vdde
    M13 (net10 inn3v 0 0) nedia_bjt w=10u l=1.25u m=(1)*(5) par1=((1)*(5)) extlay=0 xf_subext=0
    R0 (vddh out) rpp1k1 l=304.47u w=2u m=1 par1=(1)
    R1 (out net10) rpp1k1 l=507.595u w=2u m=1 par1=(1)
    I10 (in inn3v inh_ground_gnd inh_power_vdd3 inh_power_vdde) LSHVT18U3VX1
ends LS_HighSide_V3_ST

// Stimulator_TestBench/TB_OneChannel_imp/schematic
M20 (net237 net238 0 0) nedia_bjt w=30u l=1.25u m=(1)*(1) par1=((1)*(1)) extlay=0 xf_subext=0
M19 (net235 net233 0 0) nedia_bjt w=30u l=1.25u m=(1)*(1) par1=((1)*(1)) extlay=0 xf_subext=0
M2 (net207 net231 net206 0) nedia_bjt w=100.0000u l=1.25u m=(1)*(6) par1=((1)*(6)) extlay=0 xf_subext=0
M1 (net205 Ctrl_LS net206 0) nedia_bjt w=100.0000u l=1.25u m=(1)*(6) par1=((1)*(6)) extlay=0 xf_subext=0
M4 (net256 net201 0 0) nedia_bjt w=60u l=1.25u m=(1)*(1) par1=((1)*(1)) extlay=0 xf_subext=0
M6 (net197 net197 0 0) nedia_bjt w=60u l=1.25u m=(10)*(1) par1=((10)*(1)) extlay=0 xf_subext=0
M7 (VB net198 net197 0) nedia_bjt w=20u l=1.25u m=(1)*(1) par1=((1)*(1)) extlay=0 xf_subext=0
M5 (net201 VB net256 0) nedia_bjt w=60u l=1.25u m=(1)*(1) par1=((1)*(1)) extlay=0 xf_subext=0
M8 (net198 net198 VB 0) nedia_bjt w=60u l=1.25u m=(10)*(1) par1=((10)*(1)) extlay=0 xf_subext=0
M21 (net202 net202 net201 0) nedia_bjt w=30u l=1.25u m=(1)*(1) par1=((1)*(1)) extlay=0 xf_subext=0
M16 (Bias2 vdd3! net189 0) nedia_bjt w=50u l=1.25u m=(1)*(5) par1=((1)*(5)) extlay=0 xf_subext=0
M9 (net195 vdd3! 0 0) nedia_bjt w=10u l=1.25u m=(1)*(1) par1=((1)*(1)) extlay=0 xf_subext=0
M10 (net189 net195 0 0) nedia_bjt w=10u l=1.25u m=(1)*(1) par1=((1)*(1)) extlay=0 xf_subext=0
M0 (net206 VB net258 0) nedia_bjt w=60u l=1.25u m=(10)*(1) par1=((10)*(1)) extlay=0 xf_subext=0
M3 (net258 net201 0 0) nedia_bjt w=60u l=1.25u m=(10)*(1) par1=((10)*(1)) extlay=0 xf_subext=0
V10 (CAT 0) vsource dc=0 type=pulse val0=0 val1=1.8 period=500u delay=120u rise=1p fall=1p width=100u
V1 (ANO 0) vsource dc=1.8 type=pulse val0=0 val1=1.8 period=500u delay=10u rise=1p fall=1p width=100u
M25 (net207 Ctrl_HS vddh 0) ped_bjt w=100.0000u l=940.0n m=(1)*(6) par1=((1)*(6)) extlay=0 xf_subext=0
M24 (net205 net204 vddh 0) ped_bjt w=100.0000u l=940.0n m=(1)*(6) par1=((1)*(6)) extlay=0 xf_subext=0
M23 (net236 net232 vddh 0) ped_bjt w=30u l=940.0n m=(1)*(1) par1=((1)*(1)) extlay=0 xf_subext=0
M12 (net202 Bias2 net239 0) ped_bjt w=30u l=940.0n m=(1)*(1) par1=((1)*(1)) extlay=0 xf_subext=0
M11 (net239 net194 vddh 0) ped_bjt w=30u l=940.0n m=(1)*(1) par1=((1)*(1)) extlay=0 xf_subext=0
M15 (net240 net194 vddh 0) ped_bjt w=30u l=940.0n m=(1)*(1) par1=((1)*(1)) extlay=0 xf_subext=0
M18 (Bias2 Bias2 net194 0) ped_bjt w=30u l=940.0n m=(1)*(1) par1=((1)*(1)) extlay=0 xf_subext=0
M17 (net194 net194 vddh 0) ped_bjt w=30u l=940.0n m=(1)*(1) par1=((1)*(1)) extlay=0 xf_subext=0
M14 (net198 Bias2 net240 0) ped_bjt w=30u l=940.0n m=(1)*(1) par1=((1)*(1)) extlay=0 xf_subext=0
C1 (net195 0) csft5a area=6.3936e-11 perimeter=33.72u m=45 par1=(45)
C5 (vddh net195) csft5a area=6.3936e-11 perimeter=33.72u m=15 par1=(15)
M43 (vdd3! net168 net213 0) ne3 w=2u l=1u m=(1)*(1)
M37 (VBp2 net213 net174 0) ne3 w=10u l=350.0n m=(1)*(1)
M28 (net213 net174 0 0) ne3 w=10u l=350.0n m=(1)*(1)
M53 (net168 net168 0 0) ne3 w=2u l=5u m=(1)*(1)
M26 (net181 net181 0 0) ne3 w=40u l=2u m=(1)*(1)
M40 (net181 enb_3v 0 0) ne3 w=2u l=350.0n m=(1)*(1)
M13 (net189 net181 0 0) ne3 w=40u l=2u m=(1)*(10)
M50 (net246 net178 vdd3! vdd3!) pe3 w=10u l=1u m=(1)*(1)
M41 (net241 net178 vdd3! vdd3!) pe3 w=10u l=1u m=(1)*(16)
M38 (net242 net178 vdd3! vdd3!) pe3 w=10u l=1u m=(1)*(8)
M35 (net243 net178 vdd3! vdd3!) pe3 w=10u l=1u m=(1)*(4)
M32 (net244 net178 vdd3! vdd3!) pe3 w=10u l=1u m=(1)*(2)
M22 (net245 net178 vdd3! vdd3!) pe3 w=10u l=1u m=(1)*(1)
M48 (net178 net178 vdd3! vdd3!) pe3 w=10u l=1u m=(1)*(1)
M54 (net168 net168 vdd3! vdd3!) pe3 w=6u l=5u m=(1)*(1)
M51 (net213 VBp2 net246 vdd3!) pe3 w=10u l=1u m=(1)*(1)
M42 (net248 VBp2 net241 vdd3!) pe3 w=10u l=1u m=(1)*(16)
M39 (net249 VBp2 net242 vdd3!) pe3 w=10u l=1u m=(1)*(8)
M36 (net250 VBp2 net243 vdd3!) pe3 w=10u l=1u m=(1)*(4)
M33 (net251 VBp2 net244 vdd3!) pe3 w=10u l=1u m=(1)*(2)
M29 (net252 VBp2 net245 vdd3!) pe3 w=10u l=1u m=(1)*(1)
M49 (VBp2 VBp2 net178 vdd3!) pe3 w=10u l=1u m=(1)*(1)
M44 (net181 D1_3v net251 vdd3!) pe3 w=10u l=300n m=(1)*(1)
M45 (net181 D2_3v net250 vdd3!) pe3 w=10u l=300n m=(1)*(1)
M46 (net181 D3_3v net249 vdd3!) pe3 w=10u l=300n m=(1)*(1)
M47 (net181 D4_3v net248 vdd3!) pe3 w=10u l=300n m=(1)*(1)
M31 (net181 D0_3v net252 vdd3!) pe3 w=10u l=300n m=(1)*(1)
M52 (net189 en_3v vdd3! vdd3!) pe3 w=2u l=300n m=(1)*(1)
V0 (vddh 0) vsource dc=40 type=dc
V9 (EN_ST 0) vsource dc=1.8 type=dc
V8 (MAG_ST\<4\> 0) vsource dc=D4 type=dc
V7 (MAG_ST\<3\> 0) vsource dc=D3 type=dc
V6 (MAG_ST\<2\> 0) vsource dc=D2 type=dc
V5 (MAG_ST\<1\> 0) vsource dc=D1 type=dc
V2 (MAG_ST\<0\> 0) vsource dc=D0 type=dc
V4 (vdde! 0) vsource dc=1.8 type=dc
V3 (vdd3! 0) vsource dc=3.3 type=dc
I18 (en_3v enb_3v 0 vdd3!) IN_3VX2
I31 (net247 D0_3v 0 vdd3!) IN_3VX2
I3 (net253 D1_3v 0 vdd3!) IN_3VX2
I5 (net254 D2_3v 0 vdd3!) IN_3VX2
I7 (net255 D3_3v 0 vdd3!) IN_3VX2
I9 (net257 D4_3v 0 vdd3!) IN_3VX2
I34 (ANO net238 0 vdd3! vdde!) LSHVT18U3VX1
I27 (ANO net233 0 vdd3! vdde!) LSHVT18U3VX1
I17 (EN_ST en_3v 0 vdd3! vdde!) LSHVT18U3VX1
I0 (MAG_ST\<0\> net247 0 vdd3! vdde!) LSHVT18U3VX1
I30 (MAG_ST\<1\> net253 0 vdd3! vdde!) LSHVT18U3VX1
I4 (MAG_ST\<2\> net254 0 vdd3! vdde!) LSHVT18U3VX1
I6 (MAG_ST\<3\> net255 0 vdd3! vdde!) LSHVT18U3VX1
I29 (MAG_ST\<4\> net257 0 vdd3! vdde!) LSHVT18U3VX1
R2 (vddh net204) rpp1k1 l=304.47u w=2u m=1 par1=(1)
R17 (vddh net232) rpp1k1 l=304.47u w=2u m=1 par1=(1)
R8 (net204 net237) rpp1k1 l=507.595u w=2u m=1 par1=(1)
R16 (net236 net231) rpp1k1 l=507.595u w=2u m=1 par1=(1)
R18 (net232 net235) rpp1k1 l=507.595u w=2u m=1 par1=(1)
R9 (net231 0) rpp1k1 l=304.47u w=2u m=1 par1=(1)
R1 (net174 0) rpp1k1 l=150.295u w=2u m=1 par1=(1)
I33 (0 CAT Ctrl_LS vdd3! vdde! vddh 0 vdd3! vdde!) LS_LowSide_V2_ST
R0 (net205 net207) resistor r=1K
I36 (0 CAT Ctrl_HS vdd3! vdde! vddh 0 vdd3! vdde!) LS_HighSide_V3_ST
simulatorOptions options reltol=100e-6 temp=27 homotopy=all limit=delta compatible=spice2
tran tran stop=1m errpreset=conservative
save R0:1
save M3:region M3.m1:vdsat M3:vdsat M3.m1:vds M3:vds M0.m1:vds M0:vds M0.m1:vdsat M0:vdsat
