// AMS netlist generated by the AMS Unified netlister
// IC subversion:  IC6.1.8-64b.500.7
// Xcelium version: 18.03-s018
// Copyright(C) 2005-2009, Cadence Design Systems, Inc
// User: ykhuang Pid: 18573
// Design library name: EMG_202009
// Design cell name: TB_Single_Channel
// Design view name: config
// Solver: Spectre

`include "disciplines.vams"
`include "userDisciplines.vams"
// HDL file - EMG_202009, VGA, verilogams.
// HDL file - EMG_202009, BPF, verilogams.
// HDL file - EMG_202009, IA, verilogams.
// Library - EMG_202009, Cell - Single_Channel, View - schematic
// LAST TIME SAVED: Sep 22 09:26:51 2020
// NETLIST TIME: Sep 22 15:38:57 2020

`worklib EMG_202009
`view schematic

`timescale 1ns / 1ps
(* cds_ams_schematic *)

module Single_Channel (Vout, Gain_Sel, Vdda, Vinn, Vinp, Vssa);
output  Vout;
input  Gain_Sel, Vdda, Vinn, Vinp, Vssa;
wire net15;
wire net17;
IA I0 (.Vout( net15 ), .Vdda( Vdda ), .Vinn( Vinn ), .Vinp( Vinp ), .Vssa( Vssa ));
BPF I1 (.Vout( net17 ), .Vdda( Vdda ), .Vin( net15 ), .Vssa( Vssa ));
VGA I2 (.Vout( Vout ), .Gain_Sel( Gain_Sel ), .Vdda( Vdda ), .Vin( net17 ), .Vssa( Vssa ));

endmodule
// Library - EMG_202009, Cell - TB_Single_Channel, View - schematic
// LAST TIME SAVED: Sep 22 15:38:34 2020
// NETLIST TIME: Sep 22 15:38:57 2020

`worklib EMG_202009
`view schematic

`timescale 1ns / 1ps
(* cds_ams_schematic *)

module TB_Single_Channel ( );
wire net7;
wire net8;
wire Vout;
wire vdda;
Single_Channel I0 (.Vssa(cds_globals.\gnd! ), .Vdda( vdda ), .Vout( Vout ), .Gain_Sel(cds_globals.\gnd! ), .Vinn( net8 ), .Vinp( net7 ));
vsource #(.mag(1), .type("sine")) V2 (vsig, cds_globals.\gnd! );
vsource #(.dc(0), .type("dc")) V1 (Vin_CM, cds_globals.\gnd! );
vsource #(.dc(1.8), .type("dc")) V0 (vdda, cds_globals.\gnd! );
vcvs #(.gain(0.001)) E2 (Vemg, cds_globals.\gnd! , Vemg_raw, cds_globals.\gnd! );
vcvs #(.gain(-0.5)) E1 (net8, Vin_CM, Vemg, cds_globals.\gnd! );
vcvs #(.gain(0.5)) E0 (net7, Vin_CM, Vemg, cds_globals.\gnd! );
vsource #(.type("pwl"), .file("/home/ykhuang/research/Emg_Data/emg_healthy.txt")) V3 (Vemg_raw, cds_globals.\gnd! );

endmodule
`noworklib
`noview
