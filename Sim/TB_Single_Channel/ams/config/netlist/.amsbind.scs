// -----------------------------------------------------------------------------
// (c) Copyright 2010 Cadence Design Systems, Inc. All rights reserved worldwide.
// -----------------------------------------------------------------------------

// Binding AMSD Control Block for config EMG_202009.TB_Single_Channel:config
// Created On: Sep 22 15:38:59 2020
// NOTE      : DO NOT change this system generated file.

amsd {
	config designtop="EMG_202009.TB_Single_Channel:schematic"

	config cell="VGA" lib="EMG_202009" view="verilogams"
	config cell="vcvs" view="analogtext"
	config cell="BPF" lib="EMG_202009" view="verilogams"
	config cell="vsource" view="analogtext"
	config cell="Single_Channel" lib="EMG_202009" view="schematic"
	config cell="IA" lib="EMG_202009" view="verilogams"

 }
