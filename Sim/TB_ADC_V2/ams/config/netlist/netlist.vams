// AMS netlist generated by the AMS Unified netlister
// IC subversion:  IC6.1.8-64b.500.7
// Xcelium version: 18.03-s018
// Copyright(C) 2005-2009, Cadence Design Systems, Inc
// User: ykhuang Pid: 6674
// Design library name: EMG_202009
// Design cell name: TB_ADC_V2
// Design view name: config
// Solver: Spectre

`include "disciplines.vams"
`include "userDisciplines.vams"
// HDL file - EMG_202009, DAC, verilogams.
// HDL file - EMG_202009, ADC_V2, verilogams.
// Library - EMG_202009, Cell - TB_ADC_V2, View - schematic
// LAST TIME SAVED: Sep 30 14:11:37 2020
// NETLIST TIME: Sep 30 14:11:47 2020

`worklib EMG_202009
`view schematic

`timescale 1ns / 1ps
(* cds_ams_schematic *)

module TB_ADC_V2 ( );
wire [11:0] Dout;
wire VrefL;
wire VrefH;
wire Vin;
wire Start;
wire Ibias;
wire Vdda;
wire Clk;
wire EoC;
wire Vout;
ADC_V2 I0 (.Dout( Dout ), .EoC( EoC ), .Clk( Clk ), .En( Vdda ), .Ibias( Ibias ), .Start( Start ), .Vdda( Vdda ), .Vin( Vin ), .VrefH( VrefH ), .VrefL( VrefL ), .Vssa(cds_globals.\gnd! ));
DAC #(.thresh(0.9)) I4 (.Vout( Vout ), .Clk( Clk ), .Din( Dout ), .Vdda( Vdda ), .Vssa(cds_globals.\gnd! ));
vsource #(.dc(0), .type("dc")) V2 (VrefL, cds_globals.\gnd! );
vsource #(.dc(1.2), .type("dc")) V1 (VrefH, cds_globals.\gnd! );
vsource #(.dc(1.8), .type("dc")) V0 (Vdda, cds_globals.\gnd! );
vsource #(.type("pulse"), .val0(0), .val1(1.8), .period((1/32e+3)*14), .delay(0), .rise(1e-11), .fall(1e-11), .width((1/32e+3)*3)) V4 (Start, cds_globals.\gnd! );
vsource #(.type("pulse"), .val0(0), .val1(1.8), .period(1/32e+3), .delay(1/64e+3), .rise(1e-11), .fall(1e-11), .width(1/64e+3)) V3 (Clk, cds_globals.\gnd! );
isource #(.dc(1e-05), .type("dc")) I1 (Vdda, Ibias);
vsource #(.dc(0.6), .type("sine"), .ampl(0.5), .freq(500)) V5 (Vin, cds_globals.\gnd! );

endmodule
`noworklib
`noview
