// AMS netlist generated by the AMS Unified netlister
// IC subversion:  IC6.1.8-64b.500.7
// Xcelium version: 18.03-s018
// Copyright(C) 2005-2009, Cadence Design Systems, Inc
// User: ykhuang Pid: 18591
// Design library name: EMG_NMES_TestBench
// Design cell name: Sim_StimulusArtifact
// Design view name: config
// Solver: Spectre

`include "disciplines.vams"
`include "userDisciplines.vams"
// HDL file - Stimulator_Model, Digital_Stimulus_ST_V2, functional.
// HDL file - EMG_Model, IA_EMG_Ideal, verilogams.
// HDL file - EMG_Model, PGA_EMG, verilogams.
// HDL file - EMG_Model, BPF_EMG, verilogams.
// HDL file - Stimulator_Model, H_Bridge, verilogams.
// HDL file - Stimulator_Model, Current_Mirror, verilogams.
// HDL file - Stimulator_Model, Current_Source, verilogams.
// HDL file - Stimulator_Model, CH_SEL_MUX_V2, verilogams.
// Library - EMG_Model, Cell - AFE_EMG, View - schematic
// LAST TIME SAVED: Feb  9 12:37:09 2021
// NETLIST TIME: Feb 23 20:08:21 2021

`worklib EMG_Model
`view schematic

`timescale 1ns / 1ps
(* cds_ams_schematic *)

module AFE_EMG (Vout, Ibias, Vdda, Vddd, Vssa, Vssd, Vsub, Gain_Sel, Vinn, Vinp);
output  Vout;
input  Vinn, Vinp;
inout  Ibias, Vdda, Vddd, Vssa, Vssd, Vsub;
input [2:0] Gain_Sel;
wire Voutp_IA;
wire Voutn_IA;
wire Voutp_BPF;
wire Voutn_BPF;
BPF_EMG I1 (.Ibias( Ibias ), .Vdda( Vdda ), .Vssa( Vssa ), .Vsub( Vsub ), .Voutn( Voutn_BPF ), .Voutp( Voutp_BPF ), .Vinn( Voutn_IA ), .Vinp( Voutp_IA ));
PGA_EMG I2 (.Vddd( Vddd ), .Vssd( Vssd ), .Ibias( Ibias ), .Vdda( Vdda ), .Vssa( Vssa ), .Vsub( Vsub ), .Vout( Vout ), .Gain_Sel( Gain_Sel ), .Vinn( Voutn_BPF ), .Vinp( Voutp_BPF ));
IA_EMG_Ideal I0 (.Ibias( Ibias ), .Vdda( Vdda ), .Vssa( Vssa ), .Vsub( Vsub ), .Voutn( Voutn_IA ), .Voutp( Voutp_IA ), .Vinn( Vinn ), .Vinp( Vinp ));

endmodule
// Library - EMG_NMES_TestBench, Cell - Sim_StimulusArtifact, View - schematic
// LAST TIME SAVED: Feb 23 20:07:58 2021
// NETLIST TIME: Feb 23 20:08:21 2021

`worklib EMG_NMES_TestBench
`view schematic

`timescale 1ns / 1ps
(* cds_ams_schematic *)

module Sim_StimulusArtifact ( );
wire [4:0] MAG_ST;
wire [1:0] CH_SEL_D_ST;
wire [1:0] CH_SEL_U_ST;
wire [2:0] Gain_Sel;
wire EN_ST;
wire DIS_ST;
wire CAT_ST;
wire ANO_ST;
wire net025;
wire net018;
wire net019;
wire E10;
wire net020;
wire net021;
wire net022;
wire E00;
wire vssd;
wire vssa;
wire vddh;
wire vddd;
wire vdda;
wire net3;
wire Vinp;
wire Vout;
wire vsub;
wire net4;
wire net013;
wire enable;
wire net012;
Stimulator_4CH_V2 I23 (.Ibias( net3 ), .vdda( vdda ), .vddd( vddd ), .vddh( vddh ), .vssa( vssa ), .vssd( vssd ), .E00( E00 ), .E01( net022 ), .E02( net021 ), .E03( net020 ), .E10( E10 ), .E11( net019 ), .E12( net018 ), .E13( net025 ), .ANO_ST( ANO_ST ), .CAT_ST( CAT_ST ), .CH_SEL_D_ST( CH_SEL_D_ST[1:0] ), .CH_SEL_U_ST( CH_SEL_U_ST[1:0] ), .DIS_ST( DIS_ST ), .EN_ST( EN_ST ), .MAG_ST( MAG_ST[4:0] ));
AFE_EMG I1 (.Vddd( vddd ), .Vssd( vssd ), .Ibias( net4 ), .Vdda( vdda ), .Vssa( vssa ), .Vsub( vsub ), .Vout( Vout ), .Gain_Sel( Gain_Sel[2:0] ), .Vinn(cds_globals.\gnd! ), .Vinp( Vinp ));
Digital_Stimulus_ST_V2 #(.Channel_DOWN(2'b00), .period(1000)) I2 (.CH_SEL_D_ST( CH_SEL_D_ST ), .ANO_ST( ANO_ST ), .CAT_ST( CAT_ST ), .CH_SEL_U_ST( CH_SEL_U_ST ), .DIS_ST( DIS_ST ), .EN_ST( EN_ST ), .MAG_ST( MAG_ST ), .ch_sweeping( net012 ), .enable( enable ), .ramping( net013 ));
resistor #(.r(1000000)) R6 (Vinp, net09);
resistor #(.r(1000)) R9 (net017, net09);
resistor #(.r(1000000)) R5 (E10, net016);
resistor #(.r(1000)) R4 (net017, net016);
resistor #(.r(1000000)) R3 (E00, net017);
isource #(.dc(1e-05), .type("dc")) I5 (vdda, net4);
isource #(.dc(1e-05), .type("dc")) I3 (vdda, net3);
vsource #(.dc(0), .type("dc")) V20 (net012, cds_globals.\gnd! );
vsource #(.dc(0), .type("dc")) V21 (net013, cds_globals.\gnd! );
vsource #(.dc(0), .type("dc")) V19 (vssd, cds_globals.\gnd! );
vsource #(.dc(1.8), .type("dc")) V18 (vddd, cds_globals.\gnd! );
vsource #(.dc(1.8), .type("dc")) V24 (Gain_Sel[2], cds_globals.\gnd! );
vsource #(.dc(0), .type("dc")) V23 (Gain_Sel[1], cds_globals.\gnd! );
vsource #(.dc(0), .type("dc")) V22 (Gain_Sel[0], cds_globals.\gnd! );
vsource #(.dc(0), .type("dc")) V6 (vssa, cds_globals.\gnd! );
vsource #(.dc(1.8), .type("dc")) V2 (vdda, cds_globals.\gnd! );
vsource #(.dc(40), .type("dc")) V1 (vddh, cds_globals.\gnd! );
vsource #(.dc(0), .type("dc")) V4 (vsub, cds_globals.\gnd! );
vsource #(.type("pwl"), .wave({"0", "0", "1e-05", "1.8"})) V0 (enable, cds_globals.\gnd! );
capacitor #(.c(1e-09)) C1 (Vinp, net09);
capacitor #(.c(1e-09)) C3 (E10, net016);
capacitor #(.c(1e-09)) C2 (E00, net017);

endmodule
// Library - Stimulator_Model, Cell - Stimulator_4CH_V2, View - schematic
// LAST TIME SAVED: Feb 23 11:17:45 2021
// NETLIST TIME: Feb 23 20:08:21 2021

`worklib Stimulator_Model
`view schematic

`timescale 1ns / 1ps
(* cds_ams_schematic *)

module Stimulator_4CH_V2 (E00, E01, E02, E03, E10, E11, E12, E13, Ibias, vdda, vddd, vddh, vssa, vssd, ANO_ST, CAT_ST, CH_SEL_D_ST, CH_SEL_U_ST, DIS_ST, EN_ST, MAG_ST);
output  E00, E01, E02, E03, E10, E11, E12, E13;
input  ANO_ST, CAT_ST, DIS_ST, EN_ST;
inout  Ibias, vdda, vddd, vddh, vssa, vssd;
input [4:0] MAG_ST;
input [1:0] CH_SEL_D_ST;
input [1:0] CH_SEL_U_ST;
wire net32;
wire net31;
wire Iout_dac;
wire Ist;
CH_SEL_MUX_V2 I8 (.IN( net32 ), .OUT0( E10 ), .OUT1( E11 ), .OUT2( E12 ), .OUT3( E13 ), .Vdda( vdda ), .Vddd( vddd ), .Vssa( vssa ), .Vssd( vssd ), .CH_SEL( CH_SEL_D_ST ));
CH_SEL_MUX_V2 I6 (.IN( net31 ), .OUT0( E00 ), .OUT1( E01 ), .OUT2( E02 ), .OUT3( E03 ), .Vdda( vdda ), .Vddd( vddd ), .Vssa( vssa ), .Vssd( vssd ), .CH_SEL( CH_SEL_U_ST ));
Current_Source I3 (.EN( EN_ST ), .Vssd( vssd ), .Vddd( vddd ), .Ibias( Ibias ), .Vdda( vdda ), .Vssa( vssa ), .Ioutn( Iout_dac ), .Ioutp( vdda ), .Mag( MAG_ST ));
Current_Mirror I1 (.ANO( ANO_ST ), .CAT( CAT_ST ), .Iref( Iout_dac ), .EN( EN_ST ), .Iout( Ist ), .Vdda( vdda ), .Vssa( vssa ));
H_Bridge I0 (.Vssd( vssd ), .Vddd( vddd ), .Ist( Ist ), .VddH( vddh ), .Vdda( vdda ), .Vssa( vssa ), .Iano( net31 ), .Icat( net32 ), .ANO( ANO_ST ), .CAT( CAT_ST ), .DIS( DIS_ST ));

endmodule
`noworklib
`noview
