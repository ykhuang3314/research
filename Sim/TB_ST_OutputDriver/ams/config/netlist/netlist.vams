// AMS netlist generated by the AMS Unified netlister
// IC subversion:  IC6.1.8-64b.500.7
// Xcelium version: 18.03-s018
// Copyright(C) 2005-2009, Cadence Design Systems, Inc
// User: ykhuang Pid: 9799
// Design library name: Stimulator_TestBench
// Design cell name: TB_ST_OutputDriver
// Design view name: config
// Solver: Spectre

`include "disciplines.vams"
`include "userDisciplines.vams"
// HDL file - Stimulator_Model, Current_Source, verilogams.
// HDL file - Stimulator_Model, Digital_Stimulus_ST_V2, functional.
// HDL file - Stimulator_Model, Current_Mirror, verilogams.
// HDL file - Stimulator_Model, H_Brideg_V2, verilogams.
// Library - Stimulator_TestBench, Cell - TB_ST_OutputDriver, View - schematic
// LAST TIME SAVED: Feb 22 11:10:05 2021
// NETLIST TIME: Feb 22 11:15:25 2021

`worklib Stimulator_TestBench
`view schematic

`timescale 1ns / 1ps
(* cds_ams_schematic *)

module TB_ST_OutputDriver ( );
wire [1:0] CH_SEL_ST;
wire [4:0] MAG_ST;
wire DIS_ST;
wire CAT_ST;
wire ANO_ST;
wire vssd;
wire vssa;
wire vddh;
wire vddd;
wire vdda;
wire Ist;
wire EN_ST;
wire E13;
wire E12;
wire E11;
wire E10;
wire E03;
wire E02;
wire E01;
wire E00;
wire Iout_dac;
wire net14;
wire enable;
wire net13;
wire net10;
H_Brideg_V2 I0 (.E00( E00 ), .E01( E01 ), .E02( E02 ), .E03( E03 ), .E10( E10 ), .E11( E11 ), .E12( E12 ), .E13( E13 ), .EN( EN_ST ), .Ist( Ist ), .Vdda( vdda ), .Vddd( vddd ), .Vddh( vddh ), .Vssa( vssa ), .Vssd( vssd ), .ANO( ANO_ST ), .CAT( CAT_ST ), .CH_SEL_D( CH_SEL_ST ), .CH_SEL_U( CH_SEL_ST ), .DIS( DIS_ST ));
Current_Mirror I1 (.ANO( ANO_ST ), .CAT( CAT_ST ), .Iref( Iout_dac ), .EN( EN_ST ), .Iout( Ist ), .Vdda( vdda ), .Vssa( vssa ));
Digital_Stimulus_ST_V2 I2 (.ANO_ST( ANO_ST ), .CAT_ST( CAT_ST ), .CH_SEL_ST( CH_SEL_ST ), .DIS_ST( DIS_ST ), .EN_ST( EN_ST ), .MAG_ST( MAG_ST ), .ch_sweeping( net13 ), .enable( enable ), .ramping( net14 ));
Current_Source I3 (.EN( EN_ST ), .Vssd( vssd ), .Vddd( vddd ), .Ibias( net10 ), .Vdda( vdda ), .Vssa( vssa ), .Ioutn( Iout_dac ), .Ioutp( vdda ), .Mag( MAG_ST ));
isource #(.dc(1e-05), .type("dc")) I4 (vdda, net10);
resistor #(.r(1000)) R16 (net9, E13);
resistor #(.r(1000)) R15 (E03, net9);
resistor #(.r(1000)) R14 (net7, net9);
resistor #(.r(1000)) R13 (net7, E12);
resistor #(.r(1000)) R12 (E02, net7);
resistor #(.r(1000)) R11 (net5, net7);
resistor #(.r(1000)) R10 (net5, E11);
resistor #(.r(1000)) R9 (E01, net5);
resistor #(.r(1000)) R8 (net020, net5);
resistor #(.r(1000)) R1 (net020, E10);
resistor #(.r(1000)) R0 (E00, net020);
vsource #(.dc(0), .type("dc")) V8 (vssa, cds_globals.\gnd! );
vsource #(.dc(0), .type("dc")) V7 (vssd, cds_globals.\gnd! );
vsource #(.dc(40), .type("dc")) V4 (vddh, cds_globals.\gnd! );
vsource #(.dc(1.8), .type("dc")) V3 (vdda, cds_globals.\gnd! );
vsource #(.dc(1.8), .type("dc")) V6 (vddd, cds_globals.\gnd! );
vsource #(.dc(0), .type("dc")) V2 (net13, cds_globals.\gnd! );
vsource #(.dc(0), .type("dc")) V1 (net14, cds_globals.\gnd! );
vsource #(.type("pwl"), .wave({"0", "0", "1e-05", "1.8"})) V0 (enable, cds_globals.\gnd! );

endmodule
`noworklib
`noview
