// -----------------------------------------------------------------------------
// (c) Copyright 2010 Cadence Design Systems, Inc. All rights reserved worldwide.
// -----------------------------------------------------------------------------

// Binding AMSD Control Block for config Stimulator_TestBench.TB_Single_CH:config
// Created On: Feb 11 16:11:35 2021
// NOTE      : DO NOT change this system generated file.

amsd {
	config designtop="Stimulator_TestBench.TB_Single_CH:schematic"

	config cell="Digital_Stimulus_ST" lib="Stimulator_Model" view="functional"
	config cell="Current_Source" lib="Stimulator_Model" view="verilogams"
	config cell="Current_Mirror" lib="Stimulator_Model" view="verilogams"
	config cell="capacitor" view="analogtext"
	config cell="isource" view="analogtext"
	config cell="resistor" view="analogtext"
	config cell="vsource" view="analogtext"
	config cell="Stimulator_Single_CH" lib="Stimulator_Model" view="schematic"
	config cell="H_Bridge" lib="Stimulator_Model" view="verilogams"

 }
