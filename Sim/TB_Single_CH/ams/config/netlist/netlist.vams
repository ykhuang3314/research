// AMS netlist generated by the AMS Unified netlister
// IC subversion:  IC6.1.8-64b.500.7
// Xcelium version: 18.03-s018
// Copyright(C) 2005-2009, Cadence Design Systems, Inc
// User: ykhuang Pid: 5922
// Design library name: Stimulator_TestBench
// Design cell name: TB_Single_CH
// Design view name: config
// Solver: Spectre

`include "disciplines.vams"
`include "userDisciplines.vams"
// HDL file - Digital_Lib, Counter, functional.
// HDL file - Stimulator_Model, H_Bridge, verilogams.
// HDL file - Stimulator_Model, Current_Mirror, verilogams.
// HDL file - Stimulator_Model, Current_Source, verilogams.
// Library - Stimulator_TestBench, Cell - TB_Single_CH, View - schematic
// LAST TIME SAVED: Jan 19 23:45:51 2021
// NETLIST TIME: Jan 19 23:48:45 2021

`worklib Stimulator_TestBench
`view schematic

`timescale 1ns / 1ps
(* cds_ams_schematic *)

module TB_Single_CH ( );
wire [4:0] Mag;
wire net8;
wire Vssa;
wire Vdda;
wire net7;
wire net10;
wire DIS;
wire CAT;
wire ANO;
wire Vout_CAT;
wire Vout_ANO;
wire VddH;
wire CLK;
Current_Source I10 (.Ibias( net7 ), .Vdda( Vdda ), .Vssa( Vssa ), .Ioutn( net8 ), .Ioutp( Vdda ), .Mag( Mag ));
Current_Mirror I2 (.Iref( net8 ), .Iout( net10 ), .Vdda( Vdda ), .Vssa( Vssa ));
H_Bridge I3 (.Ist( net10 ), .VddH( VddH ), .Vdda( Vdda ), .Vssa( Vssa ), .Iano( Vout_ANO ), .Icat( Vout_CAT ), .ANO( ANO ), .CAT( CAT ), .DIS( DIS ));
Counter I12 (.out( Mag ), .CLK( CLK ), .EN( Vdda ), .RESET( Vssa ));
isource #(.dc(1e-05), .type("dc")) I11 (Vdda, net7);
resistor #(.r(1000000)) R5 (Vout_CAT, net05);
resistor #(.r(500)) R4 (net04, net05);
resistor #(.r(1000000)) R3 (Vout_ANO, net04);
capacitor #(.c(1e-09)) C3 (Vout_CAT, net05);
capacitor #(.c(1e-09)) C2 (Vout_ANO, net04);
vsource #(.type("pulse"), .val0(0), .val1(1.8), .period(0.00022), .delay(0.00012), .rise(1e-12), .fall(1e-12), .width(0.0001)) V3 (CAT, cds_globals.\gnd! );
vsource #(.type("pulse"), .val0(0), .val1(1.8), .period(0.00022), .delay(0.00022), .rise(1e-12), .fall(1e-12), .width(0.00011)) V4 (CLK, cds_globals.\gnd! );
vsource #(.type("pulse"), .val0(0), .val1(1.8), .period(0.00022), .delay(1e-05), .rise(1e-12), .fall(1e-12), .width(0.0001)) V0 (ANO, cds_globals.\gnd! );
vsource #(.dc(0), .type("dc")) V6 (Vssa, cds_globals.\gnd! );
vsource #(.dc(0), .type("dc")) V5 (DIS, cds_globals.\gnd! );
vsource #(.dc(30), .type("dc")) V1 (VddH, cds_globals.\gnd! );
vsource #(.dc(1.8), .type("dc")) V2 (Vdda, cds_globals.\gnd! );

endmodule
`noworklib
`noview
