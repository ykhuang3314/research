// AMS netlist generated by the AMS Unified netlister
// IC subversion:  IC6.1.8-64b.500.7
// Xcelium version: 18.03-s018
// Copyright(C) 2005-2009, Cadence Design Systems, Inc
// User: ykhuang Pid: 15215
// Design library name: EMG_TestBench
// Design cell name: TB_MultiChannel
// Design view name: config
// Solver: Spectre

`include "disciplines.vams"
`include "userDisciplines.vams"
// HDL file - EMG_Model, EMG_Clock_Gen, functional.
// HDL file - EMG_Model, DAC_EMG, verilogams.
// HDL file - EMG_Model, Digital_Stimuli_EMG, functional.
// HDL file - EMG_Model, ADC_EMG, verilogams.
// HDL file - EMG_Model, ANA_MUX_EMG, verilogams.
// HDL file - EMG_Model, IA_EMG_Ideal, verilogams.
// HDL file - EMG_Model, PGA_EMG, verilogams.
// HDL file - EMG_Model, BPF_EMG, verilogams.
// Library - EMG_TestBench, Cell - TB_MultiChannel, View - schematic
// LAST TIME SAVED: Feb 10 14:06:57 2021
// NETLIST TIME: Feb 10 14:07:11 2021

`worklib EMG_TestBench
`view schematic

`timescale 1ns / 1ps
(* cds_ams_schematic *)

module TB_MultiChannel ( );
wire [2:0] Gain_Sel;
wire [3:0] CH_Sel;
wire [0:11] net4;
wire VrefL;
wire VrefH;
wire E16;
wire E15;
wire E14;
wire E13;
wire E12;
wire E11;
wire E10;
wire E9;
wire E8;
wire E7;
wire E6;
wire E5;
wire E4;
wire E3;
wire E2;
wire E1;
wire Start;
wire CLK;
wire EoC_ADC;
wire Vdda;
wire net3;
wire Vddd;
wire CLK_DAC;
wire OUT_DAC;
MultiCH_16_EMG I3 (.Vddd( Vddd ), .Vssd(cds_globals.\gnd! ), .Ibias( net3 ), .Vdda( Vdda ), .Vssa(cds_globals.\gnd! ), .Vsub(cds_globals.\gnd! ), .Dout( net4[0:11] ), .EoC_ADC( EoC_ADC ), .CH_Sel( CH_Sel[3:0] ), .CLK_ADC( CLK ), .CLK_MUX( Start ), .E1( E1 ), .E2( E2 ), .E3( E3 ), .E4( E4 ), .E5( E5 ), .E6( E6 ), .E7( E7 ), .E8( E8 ), .E9( E9 ), .E10( E10 ), .E11( E11 ), .E12( E12 ), .E13( E13 ), .E14( E14 ), .E15( E15 ), .E16( E16 ), .En_ADC( Vdda ), .Gain_Sel( Gain_Sel[2:0] ), .Start_ADC( Start ), .Vref(cds_globals.\gnd! ), .VrefH_ADC( VrefH ), .VrefL_ADC( VrefL ));
Digital_Stimuli_EMG I4 (.CH_Sel( CH_Sel ), .start( Start ), .CLK( CLK ), .Reset(cds_globals.\gnd! ));
DAC_EMG #(.thresh(0.9)) I5 (.Vout( OUT_DAC ), .Clk( CLK_DAC ), .Din( net4 ), .Vdda( Vdda ), .Vssa(cds_globals.\gnd! ));
EMG_Clock_Gen I13 (.CLK( CLK ));
vsource #(.dc(0), .type("dc")) V6 (Gain_Sel[0], cds_globals.\gnd! );
vsource #(.dc(0), .type("dc")) V5 (Gain_Sel[1], cds_globals.\gnd! );
vsource #(.dc(0), .type("dc")) V4 (Gain_Sel[2], cds_globals.\gnd! );
vsource #(.dc(0), .type("dc")) V20 (VrefL, cds_globals.\gnd! );
vsource #(.dc(1.5), .type("dc")) V19 (VrefH, cds_globals.\gnd! );
vsource #(.dc(1.8), .type("dc")) V18 (Vdda, cds_globals.\gnd! );
vsource #(.dc(1.8), .type("dc")) V24 (Vddd, cds_globals.\gnd! );
vsource #(.type("pulse"), .val0(0), .val1(1.8), .period(1/(50e+3*14)), .delay(1/(100e+3*14)), .width(1/(100e+3*14))) V7 (CLK_DAC, cds_globals.\gnd! );
vsource #(.type("pulse"), .val0(0), .val1(1.8), .period(1/50e+3), .delay(1/100e+3), .width(1/100e+3)) V14 (net03, cds_globals.\gnd! );
vsource #(.type("sine"), .ampl(0.005), .freq(100)) V22 (E1, cds_globals.\gnd! );
vsource #(.type("sine"), .ampl(0.005), .freq(100)) V21 (E2, cds_globals.\gnd! );
vsource #(.type("sine"), .ampl(0.005), .freq(100)) V17 (E3, cds_globals.\gnd! );
vsource #(.type("sine"), .ampl(0.005), .freq(100)) V16 (E4, cds_globals.\gnd! );
vsource #(.type("sine"), .ampl(0.005), .freq(100)) V15 (E5, cds_globals.\gnd! );
vsource #(.type("sine"), .ampl(0.005), .freq(100)) V13 (E6, cds_globals.\gnd! );
vsource #(.type("sine"), .ampl(0.005), .freq(100)) V12 (E7, cds_globals.\gnd! );
vsource #(.type("sine"), .ampl(0.005), .freq(100)) V11 (E8, cds_globals.\gnd! );
vsource #(.type("sine"), .ampl(0.005), .freq(100)) V10 (E9, cds_globals.\gnd! );
vsource #(.type("sine"), .ampl(0.005), .freq(100)) V9 (E10, cds_globals.\gnd! );
vsource #(.type("sine"), .ampl(0.005), .freq(100)) V8 (E11, cds_globals.\gnd! );
vsource #(.type("sine"), .ampl(0.005), .freq(100)) V23 (E16, cds_globals.\gnd! );
vsource #(.type("sine"), .ampl(0.005), .freq(100)) V3 (E12, cds_globals.\gnd! );
vsource #(.type("sine"), .ampl(0.005), .freq(100)) V1 (E13, cds_globals.\gnd! );
vsource #(.type("sine"), .ampl(0.005), .freq(100)) V0 (E14, cds_globals.\gnd! );
vsource #(.type("sine"), .ampl(0.005), .freq(100)) V2 (E15, cds_globals.\gnd! );

endmodule
// Library - EMG_Model, Cell - AFE_EMG, View - schematic
// LAST TIME SAVED: Feb  9 12:37:09 2021
// NETLIST TIME: Feb 10 14:07:11 2021

`worklib EMG_Model
`view schematic

`timescale 1ns / 1ps
(* cds_ams_schematic *)

module AFE_EMG (Vout, Ibias, Vdda, Vddd, Vssa, Vssd, Vsub, Gain_Sel, Vinn, Vinp);
output  Vout;
input  Vinn, Vinp;
inout  Ibias, Vdda, Vddd, Vssa, Vssd, Vsub;
input [2:0] Gain_Sel;
wire Voutp_IA;
wire Voutn_IA;
wire Voutp_BPF;
wire Voutn_BPF;
BPF_EMG I1 (.Ibias( Ibias ), .Vdda( Vdda ), .Vssa( Vssa ), .Vsub( Vsub ), .Voutn( Voutn_BPF ), .Voutp( Voutp_BPF ), .Vinn( Voutn_IA ), .Vinp( Voutp_IA ));
PGA_EMG I2 (.Vddd( Vddd ), .Vssd( Vssd ), .Ibias( Ibias ), .Vdda( Vdda ), .Vssa( Vssa ), .Vsub( Vsub ), .Vout( Vout ), .Gain_Sel( Gain_Sel ), .Vinn( Voutn_BPF ), .Vinp( Voutp_BPF ));
IA_EMG_Ideal I0 (.Ibias( Ibias ), .Vdda( Vdda ), .Vssa( Vssa ), .Vsub( Vsub ), .Voutn( Voutn_IA ), .Voutp( Voutp_IA ), .Vinn( Vinn ), .Vinp( Vinp ));

endmodule
// Library - EMG_Model, Cell - MultiCH_16_EMG, View - schematic
// LAST TIME SAVED: Feb  9 13:18:29 2021
// NETLIST TIME: Feb 10 14:07:11 2021

`worklib EMG_Model
`view schematic

`timescale 1ns / 1ps
(* cds_ams_schematic *)

module MultiCH_16_EMG (Dout, EoC_ADC, Ibias, Vdda, Vddd, Vssa, Vssd, Vsub, CH_Sel, CLK_ADC, CLK_MUX, E1, E2, E3, E4, E5, E6, E7, E8, E9, E10, E11, E12, E13, E14, E15, E16, En_ADC, Gain_Sel, Start_ADC, Vref, VrefH_ADC, VrefL_ADC);
output  EoC_ADC;
input  CLK_ADC, CLK_MUX, E1, E2, E3, E4, E5, E6, E7, E8, E9, E10, E11, E12, E13, E14, E15, E16, En_ADC, Start_ADC, Vref, VrefH_ADC, VrefL_ADC;
inout  Ibias, Vdda, Vddd, Vssa, Vssd, Vsub;
output [11:0] Dout;
input [2:0] Gain_Sel;
input [3:0] CH_Sel;
wire Vout_CH16;
wire Vout_CH2;
wire Vout_CH13;
wire Vout_CH1;
wire Vout_CH14;
wire Vout_CH10;
wire Vout_CH5;
wire Vout_CH11;
wire Vout_CH7;
wire Vout_CH9;
wire Vout_CH8;
wire Vout_CH4;
wire Vout_CH6;
wire Vout_CH3;
wire Vout_CH15;
wire Vout_CH12;
wire Vin_ADC;
AFE_EMG I35 (.Vddd( Vddd ), .Vssd( Vssd ), .Ibias( Ibias ), .Vdda( Vdda ), .Vssa( Vssa ), .Vsub( Vsub ), .Vout( Vout_CH16 ), .Gain_Sel( Gain_Sel[2:0] ), .Vinn( Vref ), .Vinp( E16 ));
AFE_EMG I24 (.Vddd( Vddd ), .Vssd( Vssd ), .Ibias( Ibias ), .Vdda( Vdda ), .Vssa( Vssa ), .Vsub( Vsub ), .Vout( Vout_CH2 ), .Gain_Sel( Gain_Sel[2:0] ), .Vinn( Vref ), .Vinp( E2 ));
AFE_EMG I23 (.Vddd( Vddd ), .Vssd( Vssd ), .Ibias( Ibias ), .Vdda( Vdda ), .Vssa( Vssa ), .Vsub( Vsub ), .Vout( Vout_CH13 ), .Gain_Sel( Gain_Sel[2:0] ), .Vinn( Vref ), .Vinp( E13 ));
AFE_EMG I20 (.Vddd( Vddd ), .Vssd( Vssd ), .Ibias( Ibias ), .Vdda( Vdda ), .Vssa( Vssa ), .Vsub( Vsub ), .Vout( Vout_CH1 ), .Gain_Sel( Gain_Sel[2:0] ), .Vinn( Vref ), .Vinp( E1 ));
AFE_EMG I27 (.Vddd( Vddd ), .Vssd( Vssd ), .Ibias( Ibias ), .Vdda( Vdda ), .Vssa( Vssa ), .Vsub( Vsub ), .Vout( Vout_CH14 ), .Gain_Sel( Gain_Sel[2:0] ), .Vinn( Vref ), .Vinp( E14 ));
AFE_EMG I26 (.Vddd( Vddd ), .Vssd( Vssd ), .Ibias( Ibias ), .Vdda( Vdda ), .Vssa( Vssa ), .Vsub( Vsub ), .Vout( Vout_CH10 ), .Gain_Sel( Gain_Sel[2:0] ), .Vinn( Vref ), .Vinp( E10 ));
AFE_EMG I21 (.Vddd( Vddd ), .Vssd( Vssd ), .Ibias( Ibias ), .Vdda( Vdda ), .Vssa( Vssa ), .Vsub( Vsub ), .Vout( Vout_CH5 ), .Gain_Sel( Gain_Sel[2:0] ), .Vinn( Vref ), .Vinp( E5 ));
AFE_EMG I30 (.Vddd( Vddd ), .Vssd( Vssd ), .Ibias( Ibias ), .Vdda( Vdda ), .Vssa( Vssa ), .Vsub( Vsub ), .Vout( Vout_CH11 ), .Gain_Sel( Gain_Sel[2:0] ), .Vinn( Vref ), .Vinp( E11 ));
AFE_EMG I29 (.Vddd( Vddd ), .Vssd( Vssd ), .Ibias( Ibias ), .Vdda( Vdda ), .Vssa( Vssa ), .Vsub( Vsub ), .Vout( Vout_CH7 ), .Gain_Sel( Gain_Sel[2:0] ), .Vinn( Vref ), .Vinp( E7 ));
AFE_EMG I22 (.Vddd( Vddd ), .Vssd( Vssd ), .Ibias( Ibias ), .Vdda( Vdda ), .Vssa( Vssa ), .Vsub( Vsub ), .Vout( Vout_CH9 ), .Gain_Sel( Gain_Sel[2:0] ), .Vinn( Vref ), .Vinp( E9 ));
AFE_EMG I33 (.Vddd( Vddd ), .Vssd( Vssd ), .Ibias( Ibias ), .Vdda( Vdda ), .Vssa( Vssa ), .Vsub( Vsub ), .Vout( Vout_CH8 ), .Gain_Sel( Gain_Sel[2:0] ), .Vinn( Vref ), .Vinp( E8 ));
AFE_EMG I32 (.Vddd( Vddd ), .Vssd( Vssd ), .Ibias( Ibias ), .Vdda( Vdda ), .Vssa( Vssa ), .Vsub( Vsub ), .Vout( Vout_CH4 ), .Gain_Sel( Gain_Sel[2:0] ), .Vinn( Vref ), .Vinp( E4 ));
AFE_EMG I25 (.Vddd( Vddd ), .Vssd( Vssd ), .Ibias( Ibias ), .Vdda( Vdda ), .Vssa( Vssa ), .Vsub( Vsub ), .Vout( Vout_CH6 ), .Gain_Sel( Gain_Sel[2:0] ), .Vinn( Vref ), .Vinp( E6 ));
AFE_EMG I28 (.Vddd( Vddd ), .Vssd( Vssd ), .Ibias( Ibias ), .Vdda( Vdda ), .Vssa( Vssa ), .Vsub( Vsub ), .Vout( Vout_CH3 ), .Gain_Sel( Gain_Sel[2:0] ), .Vinn( Vref ), .Vinp( E3 ));
AFE_EMG I31 (.Vddd( Vddd ), .Vssd( Vssd ), .Ibias( Ibias ), .Vdda( Vdda ), .Vssa( Vssa ), .Vsub( Vsub ), .Vout( Vout_CH15 ), .Gain_Sel( Gain_Sel[2:0] ), .Vinn( Vref ), .Vinp( E15 ));
AFE_EMG I34 (.Vddd( Vddd ), .Vssd( Vssd ), .Ibias( Ibias ), .Vdda( Vdda ), .Vssa( Vssa ), .Vsub( Vsub ), .Vout( Vout_CH12 ), .Gain_Sel( Gain_Sel[2:0] ), .Vinn( Vref ), .Vinp( E12 ));
ANA_MUX_EMG I17 (.Vddd( Vddd ), .Vssd( Vssd ), .Vdda( Vdda ), .Vssa( Vssa ), .Vsub( Vsub ), .Vout( Vin_ADC ), .Clk( CLK_MUX ), .Vin0( Vout_CH1 ), .Vin1( Vout_CH2 ), .Vin2( Vout_CH3 ), .Vin3( Vout_CH4 ), .Vin4( Vout_CH5 ), .Vin5( Vout_CH6 ), .Vin6( Vout_CH7 ), .Vin7( Vout_CH8 ), .Vin8( Vout_CH9 ), .Vin9( Vout_CH10 ), .Vin10( Vout_CH11 ), .Vin11( Vout_CH12 ), .Vin12( Vout_CH13 ), .Vin13( Vout_CH14 ), .Vin14( Vout_CH15 ), .Vin15( Vout_CH16 ), .sel( CH_Sel ));
ADC_EMG I18 (.Vddd( Vddd ), .Vssd( Vssd ), .Ibias( Ibias ), .Vdda( Vdda ), .Vssa( Vssa ), .Vsub( Vsub ), .Dout( Dout ), .EoC( EoC_ADC ), .Clk( CLK_ADC ), .En( En_ADC ), .Start( Start_ADC ), .Vin( Vin_ADC ), .VrefH( VrefH_ADC ), .VrefL( VrefL_ADC ));

endmodule
`noworklib
`noview
