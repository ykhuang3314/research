// -----------------------------------------------------------------------------
// (c) Copyright 2010 Cadence Design Systems, Inc. All rights reserved worldwide.
// -----------------------------------------------------------------------------

// Binding AMSD Control Block for config EMG_TestBench.TB_MultiChannel:config
// Created On: Nov 18 23:55:28 2020
// NOTE      : DO NOT change this system generated file.

amsd {
	config designtop="EMG_TestBench.TB_MultiChannel:schematic"

	config cell="MultiCH_16_EMG" lib="EMG_Model" view="schematic"
	config cell="PGA_EMG" lib="EMG_Model" view="verilogams"
	config cell="IA_EMG" lib="EMG_Model" view="verilogams"
	config cell="DAC_EMG" lib="EMG_Model" view="verilogams"
	config cell="ANA_MUX_EMG" lib="EMG_Model" view="verilogams"
	config cell="BPF_EMG" lib="EMG_Model" view="verilogams"
	config cell="vsource" view="analogtext"
	config cell="AFE_EMG" lib="EMG_Model" view="schematic"
	config cell="Digital_Stimuli_EMG" lib="EMG_Model" view="functional"
	config cell="ADC_EMG" lib="EMG_Model" view="verilogams"

 }
