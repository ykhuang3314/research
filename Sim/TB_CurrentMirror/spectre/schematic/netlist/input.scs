// Design: Stimulator_TestBench/TB_CurrentMirror
simulator lang=spectre
global 0 vdde! vdd3!
parameters Iref=10u Wp=30u W=60u
include "/pkg/xfab/XKIT/xh018/cadence/v8_0/spectre/v8_0_1/lpmos/config.scs" section=default
include "/pkg/xfab/XKIT/xh018/cadence/v8_0/spectre/v8_0_1/lpmos/param.scs" section=3s
include "/pkg/xfab/XKIT/xh018/cadence/v8_0/spectre/v8_0_1/lpmos/bip.scs" section=tm
include "/pkg/xfab/XKIT/xh018/cadence/v8_0/spectre/v8_0_1/lpmos/cap.scs" section=tm
include "/pkg/xfab/XKIT/xh018/cadence/v8_0/spectre/v8_0_1/lpmos/dio.scs" section=tm
include "/pkg/xfab/XKIT/xh018/cadence/v8_0/spectre/v8_0_1/lpmos/mos.scs" section=tm
include "/pkg/xfab/XKIT/xh018/cadence/v8_0/spectre/v8_0_1/lpmos/photo.scs" section=tm
include "/pkg/xfab/XKIT/xh018/cadence/v8_0/spectre/v8_0_1/lpmos/res.scs" section=tm

// D_CELLS_M3V/LSHVT18U3VX1/cmos_sch
subckt LSHVT18U3VX1 A Q inh_ground_gnd inh_power_vdd3 inh_power_vdde
    M6 (Q net20 inh_power_vdd3 inh_power_vdd3) pe3 w=1.46u l=300n m=(1)*(1)
    M8 (net4 A inh_power_vdde inh_power_vdd3) pe3 w=1.48u l=300n m=(1)*(1)
    M9 (net20 A net024 inh_power_vdd3) pe3 w=420.0n l=300n m=(1)*(1)
    M0 (net10 net4 net023 inh_power_vdd3) pe3 w=420.0n l=300n m=(1)*(1)
    M2 (net023 net20 inh_power_vdd3 inh_power_vdd3) pe3 w=420.0n l=300n m=(1)*(1)
    M4 (net024 net10 inh_power_vdd3 inh_power_vdd3) pe3 w=420.0n l=300n m=(1)*(1)
    M3 (net20 A inh_ground_gnd inh_ground_gnd) ne3 w=1.31u l=350.0n m=(1)*(1)
    M5 (Q net20 inh_ground_gnd inh_ground_gnd) ne3 w=890.0n l=350.0n m=(1)*(1)
    M7 (net4 A inh_ground_gnd inh_ground_gnd) ne3 w=420.0n l=350.0n m=(1)*(1)
    M1 (net10 net4 inh_ground_gnd inh_ground_gnd) ne3 w=1.31u l=350.0n m=(1)*(1)
ends LSHVT18U3VX1

// GATES_3V/invrv3/schematic
subckt invrv3 in out inh_ground_gnd inh_power_vdd3
parameters GT_PDW GT_PDL=350.00n sx=4.8e-07 lc=2.7e-07 GT_PUW GT_PUL=300.00n
    MN1 (out in inh_ground_gnd inh_ground_gnd) ne3 w=GT_PDW l=GT_PDL m=(1)*(1)
    MP1 (out in inh_power_vdd3 inh_power_vdd3) pe3 w=GT_PUW l=GT_PUL m=(1)*(1)
ends invrv3

// D_CELLS_3V/IN_3VX1/cmos_sch
subckt IN_3VX1 A Q inh_ground_gnd inh_power_vdd3
    invr_1 (A Q inh_ground_gnd inh_power_vdd3) invrv3 GT_PDW=600.00n GT_PDL=350.00n sx=4.8e-07 lc=2.7e-07 GT_PUW=1.41u GT_PUL=300.00n
ends IN_3VX1

// Stimulator_TestBench/TB_CurrentMirror/schematic
M21 (net034 net034 net011 0) nedia_bjt w=15.0u l=1.25u m=(1)*(1) par1=((1)*(1)) extlay=0 xf_subext=0
M16 (Bias2 vdd3 net078 0) nedia_bjt w=50u l=1.25u m=(1)*(5) par1=((1)*(5)) extlay=0 xf_subext=0
M8 (net02 net02 VB 0) nedia_bjt w=W l=1.25u m=(1)*(1) par1=((1)*(1)) extlay=0 xf_subext=0
M7 (VB net02 net01 0) nedia_bjt w=(W/3) l=1.25u m=(1)*(1) par1=((1)*(1)) extlay=0 xf_subext=0
M6 (net01 net01 0 0) nedia_bjt w=W l=1.25u m=(1)*(1) par1=((1)*(1)) extlay=0 xf_subext=0
M5 (net011 VB net07 0) nedia_bjt w=W l=1.25u m=(1)*(1) par1=((1)*(1)) extlay=0 xf_subext=0
M4 (net07 net011 0 0) nedia_bjt w=W l=1.25u m=(1)*(1) par1=((1)*(1)) extlay=0 xf_subext=0
M0 (net8 VB net1 0) nedia_bjt w=W l=1.25u m=(1)*(10) par1=((1)*(10)) extlay=0 xf_subext=0
M3 (net1 net011 0 0) nedia_bjt w=W l=1.25u m=(1)*(10) par1=((1)*(10)) extlay=0 xf_subext=0
R0 (vddh net8) resistor r=1.1k
M12 (net034 Bias2 net021 0) ped_bjt w=Wp l=940.0n m=(1)*(1) par1=((1)*(1)) extlay=0 xf_subext=0
M11 (net021 Bias1 vddh 0) ped_bjt w=Wp l=940.0n m=(1)*(1) par1=((1)*(1)) extlay=0 xf_subext=0
M10 (net02 Bias2 net013 0) ped_bjt w=Wp l=940.0n m=(1)*(1) par1=((1)*(1)) extlay=0 xf_subext=0
M9 (Bias2 Bias2 Bias1 0) ped_bjt w=Wp l=940.0n m=(1)*(1) par1=((1)*(1)) extlay=0 xf_subext=0
M1 (net013 Bias1 vddh 0) ped_bjt w=Wp l=940.0n m=(1)*(1) par1=((1)*(1)) extlay=0 xf_subext=0
M2 (Bias1 Bias1 vddh 0) ped_bjt w=Wp l=940.0n m=(1)*(1) par1=((1)*(1)) extlay=0 xf_subext=0
V6 (net070 0) vsource dc=1.8 type=dc
V4 (vdde! 0) vsource dc=1.8 type=dc
V3 (vdd3! 0) vsource dc=3.3 type=dc
V1 (vdd3 0) vsource dc=3.3 type=dc
V0 (vddh 0) vsource dc=40 type=dc
I22 (vdd3 net068) isource dc=Iref type=dc
M53 (net071 net071 0 0) ne3 w=2u l=5u m=(1)*(1)
M43 (vdd3 net071 net074 0) ne3 w=2u l=1u m=(1)*(1)
M40 (net068 enb_3v 0 0) ne3 w=2u l=350.0n m=(1)*(1)
M37 (VBp2 net074 net075 0) ne3 w=10u l=350.0n m=(1)*(1)
M28 (net074 net075 0 0) ne3 w=10u l=350.0n m=(1)*(1)
M26 (net068 net068 0 0) ne3 w=40u l=2u m=(1)*(1)
M13 (net078 net068 0 0) ne3 w=40u l=2u m=(1)*(10)
M54 (net071 net071 vdd3 vdd3) pe3 w=6u l=5u m=(1)*(1)
M52 (net078 en_3v vdd3 vdd3) pe3 w=2u l=300n m=(1)*(1)
M51 (net074 VBp2 net047 vdd3) pe3 w=10u l=1u m=(1)*(1)
M50 (net047 VBp1 vdd3 vdd3) pe3 w=10u l=1u m=(1)*(1)
M44 (0 0 net044 vdd3) pe3 w=10u l=300n m=(1)*(1)
M42 (net038 VBp2 net037 vdd3) pe3 w=10u l=1u m=(1)*(16)
M41 (net037 VBp1 vdd3 vdd3) pe3 w=10u l=1u m=(1)*(16)
M45 (0 0 net042 vdd3) pe3 w=10u l=300n m=(1)*(1)
M39 (net040 VBp2 net039 vdd3) pe3 w=10u l=1u m=(1)*(8)
M38 (net039 VBp1 vdd3 vdd3) pe3 w=10u l=1u m=(1)*(8)
M46 (0 0 net040 vdd3) pe3 w=10u l=300n m=(1)*(1)
M36 (net042 VBp2 net041 vdd3) pe3 w=10u l=1u m=(1)*(4)
M35 (net041 VBp1 vdd3 vdd3) pe3 w=10u l=1u m=(1)*(4)
M47 (0 0 net038 vdd3) pe3 w=10u l=300n m=(1)*(1)
M33 (net044 VBp2 net043 vdd3) pe3 w=10u l=1u m=(1)*(2)
M32 (net043 VBp1 vdd3 vdd3) pe3 w=10u l=1u m=(1)*(2)
M31 (0 0 net049 vdd3) pe3 w=10u l=300n m=(1)*(1)
M29 (net049 VBp2 net045 vdd3) pe3 w=10u l=1u m=(1)*(1)
M22 (net045 VBp1 vdd3 vdd3) pe3 w=10u l=1u m=(1)*(1)
M49 (VBp2 VBp2 VBp1 vdd3) pe3 w=10u l=1u m=(1)*(1)
M48 (VBp1 VBp1 vdd3 vdd3) pe3 w=10u l=1u m=(1)*(1)
I17 (net070 en_3v 0 vdd3! vdde!) LSHVT18U3VX1
I18 (en_3v enb_3v 0 vdd3!) IN_3VX1
R1 (net075 0) rpp1k1 l=150.295u w=2u m=1 par1=(1)
simulatorOptions options reltol=100e-6 temp=27 homotopy=all limit=delta compatible=spice2
dcOp dc
save M26:1 M9:1 M10:1 M5:1 R0:1
