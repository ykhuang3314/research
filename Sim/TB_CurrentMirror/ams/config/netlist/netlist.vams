// AMS netlist generated by the AMS Unified netlister
// IC subversion:  IC6.1.8-64b.500.7
// Xcelium version: 18.03-s018
// Copyright(C) 2005-2009, Cadence Design Systems, Inc
// User: ykhuang Pid: 9651
// Design library name: Stimulator_TestBench
// Design cell name: TB_CurrentMirror
// Design view name: config
// Solver: Spectre

`include "disciplines.vams"
`include "userDisciplines.vams"
// HDL file - Stimulator_Model, Digital_Stimulus_ST_V2, functional.
// Library - GATES_3V, Cell - invrv3, View - schematic
// LAST TIME SAVED: Mar  7 12:42:39 2018
// NETLIST TIME: Mar 22 15:02:27 2021

`worklib GATES_3V
`view schematic

`timescale 1ns / 1ps
(* cds_ams_schematic *)

module invrv3 (out, in);
output  out;
input  in;
wire (*
integer inh_conn_prop_name = "power_vdd3";
integer inh_conn_def_value = "cds_globals.\\vdd3! "; *)
\vdd3! ;
wire (*
integer inh_conn_prop_name = "ground_gnd";
integer inh_conn_def_value = "cds_globals.\\gnd! "; *)
\gnd! ;
parameter GT_PDW=0 ;
parameter GT_PDL=3.5e-07 ;
parameter sx=4.8e-07 ;
parameter lc=2.7e-07 ;
parameter GT_PUW=0 ;
parameter GT_PUL=3e-07 ;
ne3 #(.w(GT_PDW), .l(GT_PDL), .as(sx*(GT_PDW)), .ad(sx*(GT_PDW)), .ps(2*sx+(GT_PDW)), .pd(2*sx+(GT_PDW)), .nrs(lc/(GT_PDW)), .nrd(lc/(GT_PDW)), .m((1)*(1)), .par1((1)*(1)), .xf_subext(0))
(* integer passed_mfactor = "m"; *)
 MN1 (out, in, \gnd! , \gnd! );
pe3 #(.w(GT_PUW), .l(GT_PUL), .as(sx*(GT_PUW)), .ad(sx*(GT_PUW)), .ps(2*sx+(GT_PUW)), .pd(2*sx+(GT_PUW)), .nrs(lc/(GT_PUW)), .nrd(lc/(GT_PUW)), .m((1)*(1)), .par1((1)*(1)))
(* integer passed_mfactor = "m"; *)
 MP1 (out, in, \vdd3! , \vdd3! );

endmodule
// Library - D_CELLS_3V, Cell - IN_3VX2, View - cmos_sch
// LAST TIME SAVED: Feb 20 10:23:55 2018
// NETLIST TIME: Mar 22 15:02:27 2021

`worklib D_CELLS_3V
`view cmos_sch

`timescale 1ns / 1ps
(* cds_ams_schematic *)

module IN_3VX2 (Q, A);
output  Q;
input  A;
wire (*
integer inh_conn_prop_name = "power_vdd3";
integer inh_conn_def_value = "cds_globals.\\vdd3! "; *)
\vdd3! ;
wire (*
integer inh_conn_prop_name = "ground_gnd";
integer inh_conn_def_value = "cds_globals.\\gnd! "; *)
\gnd! ;
invrv3 #(.sx(4.8e-07), .GT_PUW(2.94e-06), .GT_PDL(3.5e-07), .lc(2.7e-07), .GT_PUL(3e-07), .GT_PDW(9.6e-07)) invr_1 (.in( A ), .out( Q ));

endmodule
// Library - Stimulator_TestBench, Cell - TB_CurrentMirror, View - schematic
// LAST TIME SAVED: Mar 22 15:02:08 2021
// NETLIST TIME: Mar 22 15:02:27 2021

`worklib Stimulator_TestBench
`view schematic

`timescale 1ns / 1ps
(* cds_ams_schematic *)

module TB_CurrentMirror ( );
wire [4:0] MAG_ST;
wire [0:1] net080;
wire [0:1] net079;
wire net050;
wire net048;
wire net083;
wire EN_ST;
wire net056;
wire net057;
wire net058;
wire net051;
wire net052;
wire net053;
wire net054;
wire net055;
wire en_3v;
wire enb_3v;
wire D0_3v;
wire D1_3v;
wire D2_3v;
wire D3_3v;
wire D4_3v;
Digital_Stimulus_ST_V2 #(.MAG(5'b11111), .ANO_phase(50), .CAT_phase(50), .period(150)) I24 (.CH_SEL_D_ST( net079 ), .ANO_ST( net058 ), .CAT_ST( net057 ), .CH_SEL_U_ST( net080 ), .DIS_ST( net056 ), .EN_ST( EN_ST ), .MAG_ST( MAG_ST ), .ch_sweeping( net083 ), .enable( net048 ), .ramping( net050 ));
LSHVT18U3VX1 I0 (.A( MAG_ST[0] ), .Q( net051 ));
LSHVT18U3VX1 I30 (.A( MAG_ST[1] ), .Q( net052 ));
LSHVT18U3VX1 I4 (.A( MAG_ST[2] ), .Q( net053 ));
LSHVT18U3VX1 I6 (.A( MAG_ST[3] ), .Q( net054 ));
LSHVT18U3VX1 I29 (.A( MAG_ST[4] ), .Q( net055 ));
LSHVT18U3VX1 I17 (.A( EN_ST ), .Q( en_3v ));
IN_3VX2 I18 (.A( en_3v ), .Q( enb_3v ));
IN_3VX2 I31 (.A( net051 ), .Q( D0_3v ));
IN_3VX2 I3 (.A( net052 ), .Q( D1_3v ));
IN_3VX2 I5 (.A( net053 ), .Q( D2_3v ));
IN_3VX2 I7 (.A( net054 ), .Q( D3_3v ));
IN_3VX2 I9 (.A( net055 ), .Q( D4_3v ));
nedia_bjt #(.w(1.5e-05), .l(1.25e-06), .m((1)*(1)), .par1((1)*(1)), .extlay(0), .xf_subext(0))
(* integer passed_mfactor = "m"; *)
 M21 (net034, net034, net011, cds_globals.\gnd! );
nedia_bjt #(.w(5e-05), .l(1.25e-06), .m((1)*(5)), .par1((1)*(5)), .extlay(0), .xf_subext(0))
(* integer passed_mfactor = "m"; *)
 M16 (Bias2, vdd3, net078, cds_globals.\gnd! );
nedia_bjt #(.w(cds_globals.W), .l(1.25e-06), .m((1)*(1)), .par1((1)*(1)), .extlay(0), .xf_subext(0))
(* integer passed_mfactor = "m"; *)
 M8 (net02, net02, VB, cds_globals.\gnd! );
nedia_bjt #(.w(cds_globals.W/3), .l(1.25e-06), .m((1)*(1)), .par1((1)*(1)), .extlay(0), .xf_subext(0))
(* integer passed_mfactor = "m"; *)
 M7 (VB, net02, net01, cds_globals.\gnd! );
nedia_bjt #(.w(cds_globals.W), .l(1.25e-06), .m((1)*(1)), .par1((1)*(1)), .extlay(0), .xf_subext(0))
(* integer passed_mfactor = "m"; *)
 M6 (net01, net01, cds_globals.\gnd! , cds_globals.\gnd! );
nedia_bjt #(.w(cds_globals.W), .l(1.25e-06), .m((1)*(1)), .par1((1)*(1)), .extlay(0), .xf_subext(0))
(* integer passed_mfactor = "m"; *)
 M5 (net011, VB, net07, cds_globals.\gnd! );
nedia_bjt #(.w(cds_globals.W), .l(1.25e-06), .m((1)*(1)), .par1((1)*(1)), .extlay(0), .xf_subext(0))
(* integer passed_mfactor = "m"; *)
 M4 (net07, net011, cds_globals.\gnd! , cds_globals.\gnd! );
nedia_bjt #(.w(cds_globals.W), .l(1.25e-06), .m((1)*(10)), .par1((1)*(10)), .extlay(0), .xf_subext(0))
(* integer passed_mfactor = "m"; *)
 M0 (net8, VB, net1, cds_globals.\gnd! );
nedia_bjt #(.w(cds_globals.W), .l(1.25e-06), .m((1)*(10)), .par1((1)*(10)), .extlay(0), .xf_subext(0))
(* integer passed_mfactor = "m"; *)
 M3 (net1, net011, cds_globals.\gnd! , cds_globals.\gnd! );
resistor #(.r(1100)) R0 (vddh, net8);
ped_bjt #(.w(cds_globals.Wp), .l(9.4e-07), .m((1)*(1)), .par1((1)*(1)), .extlay(0), .xf_subext(0))
(* integer passed_mfactor = "m"; *)
 M12 (net034, Bias2, net021, cds_globals.\gnd! );
ped_bjt #(.w(cds_globals.Wp), .l(9.4e-07), .m((1)*(1)), .par1((1)*(1)), .extlay(0), .xf_subext(0))
(* integer passed_mfactor = "m"; *)
 M11 (net021, Bias1, vddh, cds_globals.\gnd! );
ped_bjt #(.w(cds_globals.Wp), .l(9.4e-07), .m((1)*(1)), .par1((1)*(1)), .extlay(0), .xf_subext(0))
(* integer passed_mfactor = "m"; *)
 M10 (net02, Bias2, net013, cds_globals.\gnd! );
ped_bjt #(.w(cds_globals.Wp), .l(9.4e-07), .m((1)*(1)), .par1((1)*(1)), .extlay(0), .xf_subext(0))
(* integer passed_mfactor = "m"; *)
 M9 (Bias2, Bias2, Bias1, cds_globals.\gnd! );
ped_bjt #(.w(cds_globals.Wp), .l(9.4e-07), .m((1)*(1)), .par1((1)*(1)), .extlay(0), .xf_subext(0))
(* integer passed_mfactor = "m"; *)
 M1 (net013, Bias1, vddh, cds_globals.\gnd! );
ped_bjt #(.w(cds_globals.Wp), .l(9.4e-07), .m((1)*(1)), .par1((1)*(1)), .extlay(0), .xf_subext(0))
(* integer passed_mfactor = "m"; *)
 M2 (Bias1, Bias1, vddh, cds_globals.\gnd! );
vsource #(.dc(1.8), .type("dc")) V4 (cds_globals.\vdde! , cds_globals.\gnd! );
vsource #(.dc(3.3), .type("dc")) V3 (cds_globals.\vdd3! , cds_globals.\gnd! );
vsource #(.dc(1.8), .type("dc")) V8 (net050, cds_globals.\gnd! );
vsource #(.dc(0), .type("dc")) V7 (net083, cds_globals.\gnd! );
vsource #(.dc(3.3), .type("dc")) V1 (vdd3, cds_globals.\gnd! );
vsource #(.dc(40), .type("dc")) V0 (vddh, cds_globals.\gnd! );
ne3 #(.w(1e-05), .l(3.5e-07), .as(4.8e-12), .ad(4.8e-12), .ps(2.096e-05), .pd(2.096e-05), .nrs(0.027), .nrd(0.027), .m((1)*(1)), .par1((1)*(1)), .xf_subext(0))
(* integer passed_mfactor = "m"; *)
 M37 (VBp2, net074, net075, cds_globals.\gnd! );
ne3 #(.w(1e-05), .l(3.5e-07), .as(4.8e-12), .ad(4.8e-12), .ps(2.096e-05), .pd(2.096e-05), .nrs(0.027), .nrd(0.027), .m((1)*(1)), .par1((1)*(1)), .xf_subext(0))
(* integer passed_mfactor = "m"; *)
 M28 (net074, net075, cds_globals.\gnd! , cds_globals.\gnd! );
ne3 #(.w(4e-05), .l(2e-06), .as(1.92e-11), .ad(1.92e-11), .ps(8.096e-05), .pd(8.096e-05), .nrs(0.00675), .nrd(0.00675), .m((1)*(1)), .par1((1)*(1)), .xf_subext(0))
(* integer passed_mfactor = "m"; *)
 M26 (net068, net068, cds_globals.\gnd! , cds_globals.\gnd! );
ne3 #(.w(2e-06), .l(3.5e-07), .as(9.6e-13), .ad(9.6e-13), .ps(4.96e-06), .pd(4.96e-06), .nrs(0.135), .nrd(0.135), .m((1)*(1)), .par1((1)*(1)), .xf_subext(0))
(* integer passed_mfactor = "m"; *)
 M40 (net068, enb_3v, cds_globals.\gnd! , cds_globals.\gnd! );
ne3 #(.w(2e-06), .l(5e-06), .as(9.6e-13), .ad(9.6e-13), .ps(4.96e-06), .pd(4.96e-06), .nrs(0.135), .nrd(0.135), .m((1)*(1)), .par1((1)*(1)), .xf_subext(0))
(* integer passed_mfactor = "m"; *)
 M53 (net071, net071, cds_globals.\gnd! , cds_globals.\gnd! );
ne3 #(.w(4e-05), .l(2e-06), .as(1.248e-11), .ad(1.08e-11), .ps(4.8624e-05), .pd(4.054e-05), .nrs(0.00675), .nrd(0.00675), .m((1)*(10)), .par1((1)*(10)), .xf_subext(0))
(* integer passed_mfactor = "m"; *)
 M13 (net078, net068, cds_globals.\gnd! , cds_globals.\gnd! );
ne3 #(.w(2e-06), .l(1e-06), .as(9.6e-13), .ad(9.6e-13), .ps(4.96e-06), .pd(4.96e-06), .nrs(0.135), .nrd(0.135), .m((1)*(1)), .par1((1)*(1)), .xf_subext(0))
(* integer passed_mfactor = "m"; *)
 M43 (vdd3, net071, net074, cds_globals.\gnd! );
pe3 #(.w(1e-05), .l(1e-06), .as(4.8e-12), .ad(4.8e-12), .ps(2.096e-05), .pd(2.096e-05), .nrs(0.027), .nrd(0.027), .m((1)*(1)), .par1((1)*(1)))
(* integer passed_mfactor = "m"; *)
 M51 (net074, VBp2, net047, vdd3);
pe3 #(.w(1e-05), .l(1e-06), .as(4.8e-12), .ad(4.8e-12), .ps(2.096e-05), .pd(2.096e-05), .nrs(0.027), .nrd(0.027), .m((1)*(1)), .par1((1)*(1)))
(* integer passed_mfactor = "m"; *)
 M50 (net047, VBp1, vdd3, vdd3);
pe3 #(.w(1e-05), .l(3e-07), .as(4.8e-12), .ad(4.8e-12), .ps(2.096e-05), .pd(2.096e-05), .nrs(0.027), .nrd(0.027), .m((1)*(1)), .par1((1)*(1)))
(* integer passed_mfactor = "m"; *)
 M44 (net068, D1_3v, net044, vdd3);
pe3 #(.w(1e-05), .l(1e-06), .as(2.9625e-12), .ad(2.7e-12), .ps(1.18425e-05), .pd(1.054e-05), .nrs(0.027), .nrd(0.027), .m((1)*(16)), .par1((1)*(16)))
(* integer passed_mfactor = "m"; *)
 M42 (net038, VBp2, net037, vdd3);
pe3 #(.w(1e-05), .l(1e-06), .as(2.9625e-12), .ad(2.7e-12), .ps(1.18425e-05), .pd(1.054e-05), .nrs(0.027), .nrd(0.027), .m((1)*(16)), .par1((1)*(16)))
(* integer passed_mfactor = "m"; *)
 M41 (net037, VBp1, vdd3, vdd3);
pe3 #(.w(1e-05), .l(3e-07), .as(4.8e-12), .ad(4.8e-12), .ps(2.096e-05), .pd(2.096e-05), .nrs(0.027), .nrd(0.027), .m((1)*(1)), .par1((1)*(1)))
(* integer passed_mfactor = "m"; *)
 M45 (net068, D2_3v, net042, vdd3);
pe3 #(.w(1e-05), .l(1e-06), .as(3.225e-12), .ad(2.7e-12), .ps(1.3145e-05), .pd(1.054e-05), .nrs(0.027), .nrd(0.027), .m((1)*(8)), .par1((1)*(8)))
(* integer passed_mfactor = "m"; *)
 M39 (net040, VBp2, net039, vdd3);
pe3 #(.w(1e-05), .l(1e-06), .as(3.225e-12), .ad(2.7e-12), .ps(1.3145e-05), .pd(1.054e-05), .nrs(0.027), .nrd(0.027), .m((1)*(8)), .par1((1)*(8)))
(* integer passed_mfactor = "m"; *)
 M38 (net039, VBp1, vdd3, vdd3);
pe3 #(.w(1e-05), .l(3e-07), .as(4.8e-12), .ad(4.8e-12), .ps(2.096e-05), .pd(2.096e-05), .nrs(0.027), .nrd(0.027), .m((1)*(1)), .par1((1)*(1)))
(* integer passed_mfactor = "m"; *)
 M46 (net068, D3_3v, net040, vdd3);
pe3 #(.w(1e-05), .l(1e-06), .as(3.75e-12), .ad(2.7e-12), .ps(1.575e-05), .pd(1.054e-05), .nrs(0.027), .nrd(0.027), .m((1)*(4)), .par1((1)*(4)))
(* integer passed_mfactor = "m"; *)
 M36 (net042, VBp2, net041, vdd3);
pe3 #(.w(1e-05), .l(1e-06), .as(3.75e-12), .ad(2.7e-12), .ps(1.575e-05), .pd(1.054e-05), .nrs(0.027), .nrd(0.027), .m((1)*(4)), .par1((1)*(4)))
(* integer passed_mfactor = "m"; *)
 M35 (net041, VBp1, vdd3, vdd3);
pe3 #(.w(1e-05), .l(3e-07), .as(4.8e-12), .ad(4.8e-12), .ps(2.096e-05), .pd(2.096e-05), .nrs(0.027), .nrd(0.027), .m((1)*(1)), .par1((1)*(1)))
(* integer passed_mfactor = "m"; *)
 M47 (net068, D4_3v, net038, vdd3);
pe3 #(.w(1e-05), .l(1e-06), .as(4.8e-12), .ad(2.7e-12), .ps(2.096e-05), .pd(1.054e-05), .nrs(0.027), .nrd(0.027), .m((1)*(2)), .par1((1)*(2)))
(* integer passed_mfactor = "m"; *)
 M33 (net044, VBp2, net043, vdd3);
pe3 #(.w(1e-05), .l(1e-06), .as(4.8e-12), .ad(2.7e-12), .ps(2.096e-05), .pd(1.054e-05), .nrs(0.027), .nrd(0.027), .m((1)*(2)), .par1((1)*(2)))
(* integer passed_mfactor = "m"; *)
 M32 (net043, VBp1, vdd3, vdd3);
pe3 #(.w(1e-05), .l(3e-07), .as(4.8e-12), .ad(4.8e-12), .ps(2.096e-05), .pd(2.096e-05), .nrs(0.027), .nrd(0.027), .m((1)*(1)), .par1((1)*(1)))
(* integer passed_mfactor = "m"; *)
 M31 (net068, D0_3v, net049, vdd3);
pe3 #(.w(1e-05), .l(1e-06), .as(4.8e-12), .ad(4.8e-12), .ps(2.096e-05), .pd(2.096e-05), .nrs(0.027), .nrd(0.027), .m((1)*(1)), .par1((1)*(1)))
(* integer passed_mfactor = "m"; *)
 M29 (net049, VBp2, net045, vdd3);
pe3 #(.w(2e-06), .l(3e-07), .as(9.6e-13), .ad(9.6e-13), .ps(4.96e-06), .pd(4.96e-06), .nrs(0.135), .nrd(0.135), .m((1)*(1)), .par1((1)*(1)))
(* integer passed_mfactor = "m"; *)
 M52 (net078, en_3v, vdd3, vdd3);
pe3 #(.w(1e-05), .l(1e-06), .as(4.8e-12), .ad(4.8e-12), .ps(2.096e-05), .pd(2.096e-05), .nrs(0.027), .nrd(0.027), .m((1)*(1)), .par1((1)*(1)))
(* integer passed_mfactor = "m"; *)
 M22 (net045, VBp1, vdd3, vdd3);
pe3 #(.w(6e-06), .l(5e-06), .as(2.88e-12), .ad(2.88e-12), .ps(1.296e-05), .pd(1.296e-05), .nrs(0.045), .nrd(0.045), .m((1)*(1)), .par1((1)*(1)))
(* integer passed_mfactor = "m"; *)
 M54 (net071, net071, vdd3, vdd3);
pe3 #(.w(1e-05), .l(1e-06), .as(4.8e-12), .ad(4.8e-12), .ps(2.096e-05), .pd(2.096e-05), .nrs(0.027), .nrd(0.027), .m((1)*(1)), .par1((1)*(1)))
(* integer passed_mfactor = "m"; *)
 M49 (VBp2, VBp2, VBp1, vdd3);
pe3 #(.w(1e-05), .l(1e-06), .as(4.8e-12), .ad(4.8e-12), .ps(2.096e-05), .pd(2.096e-05), .nrs(0.027), .nrd(0.027), .m((1)*(1)), .par1((1)*(1)))
(* integer passed_mfactor = "m"; *)
 M48 (VBp1, VBp1, vdd3, vdd3);
rpp1k1 #(.l(0.000150295), .w(2e-06), .m(1), .par1(1))
(* integer passed_mfactor = "m"; *)
 R1 (net075, cds_globals.\gnd! );
vsource #(.type("pwl"), .wave({"0", "0", "1e-11", "1.8"})) V2 (net048, cds_globals.\gnd! );

endmodule
// Library - D_CELLS_M3V, Cell - LSHVT18U3VX1, View - cmos_sch
// LAST TIME SAVED: Jun  7 14:44:58 2018
// NETLIST TIME: Mar 22 15:02:27 2021

`worklib D_CELLS_M3V
`view cmos_sch

`timescale 1ns / 1ps
(* cds_ams_schematic *)

module LSHVT18U3VX1 (Q, A);
output  Q;
input  A;
wire (*
integer inh_conn_prop_name = "power_vdd3";
integer inh_conn_def_value = "cds_globals.\\vdd3! "; *)
\vdd3! ;
wire (*
integer inh_conn_prop_name = "ground_gnd";
integer inh_conn_def_value = "cds_globals.\\gnd! "; *)
\gnd! ;
wire (*
integer inh_conn_prop_name = "power_vdde";
integer inh_conn_def_value = "cds_globals.\\vdde! "; *)
\vdde! ;
pe3 #(.w(1.46e-06), .l(3e-07), .as(7.008e-13), .ad(7.008e-13), .ps(3.88e-06), .pd(3.88e-06), .nrs(0.184932), .nrd(0.184932), .m((1)*(1)), .par1((1)*(1)))
(* integer passed_mfactor = "m"; *)
 M6 (Q, net20, \vdd3! , \vdd3! );
pe3 #(.w(1.48e-06), .l(3e-07), .as(7.104e-13), .ad(7.104e-13), .ps(3.92e-06), .pd(3.92e-06), .nrs(0.182432), .nrd(0.182432), .m((1)*(1)), .par1((1)*(1)))
(* integer passed_mfactor = "m"; *)
 M8 (net4, A, \vdde! , \vdd3! );
pe3 #(.w(4.2e-07), .l(3e-07), .as(2.016e-13), .ad(2.016e-13), .ps(1.8e-06), .pd(1.8e-06), .nrs(0.642857), .nrd(0.642857), .m((1)*(1)), .par1((1)*(1)))
(* integer passed_mfactor = "m"; *)
 M9 (net20, A, net024, \vdd3! );
pe3 #(.w(4.2e-07), .l(3e-07), .as(2.016e-13), .ad(2.016e-13), .ps(1.8e-06), .pd(1.8e-06), .nrs(0.642857), .nrd(0.642857), .m((1)*(1)), .par1((1)*(1)))
(* integer passed_mfactor = "m"; *)
 M0 (net10, net4, net023, \vdd3! );
pe3 #(.w(4.2e-07), .l(3e-07), .as(2.016e-13), .ad(2.016e-13), .ps(1.8e-06), .pd(1.8e-06), .nrs(0.642857), .nrd(0.642857), .m((1)*(1)), .par1((1)*(1)))
(* integer passed_mfactor = "m"; *)
 M2 (net023, net20, \vdd3! , \vdd3! );
pe3 #(.w(4.2e-07), .l(3e-07), .as(2.016e-13), .ad(2.016e-13), .ps(1.8e-06), .pd(1.8e-06), .nrs(0.642857), .nrd(0.642857), .m((1)*(1)), .par1((1)*(1)))
(* integer passed_mfactor = "m"; *)
 M4 (net024, net10, \vdd3! , \vdd3! );
ne3 #(.w(1.31e-06), .l(3.5e-07), .as(6.288e-13), .ad(6.288e-13), .ps(3.58e-06), .pd(3.58e-06), .nrs(0.206107), .nrd(0.206107), .m((1)*(1)), .par1((1)*(1)), .xf_subext(0))
(* integer passed_mfactor = "m"; *)
 M3 (net20, A, \gnd! , \gnd! );
ne3 #(.w(8.9e-07), .l(3.5e-07), .as(4.272e-13), .ad(4.272e-13), .ps(2.74e-06), .pd(2.74e-06), .nrs(0.303371), .nrd(0.303371), .m((1)*(1)), .par1((1)*(1)), .xf_subext(0))
(* integer passed_mfactor = "m"; *)
 M5 (Q, net20, \gnd! , \gnd! );
ne3 #(.w(4.2e-07), .l(3.5e-07), .as(2.016e-13), .ad(2.016e-13), .ps(1.8e-06), .pd(1.8e-06), .nrs(0.642857), .nrd(0.642857), .m((1)*(1)), .par1((1)*(1)), .xf_subext(0))
(* integer passed_mfactor = "m"; *)
 M7 (net4, A, \gnd! , \gnd! );
ne3 #(.w(1.31e-06), .l(3.5e-07), .as(6.288e-13), .ad(6.288e-13), .ps(3.58e-06), .pd(3.58e-06), .nrs(0.206107), .nrd(0.206107), .m((1)*(1)), .par1((1)*(1)), .xf_subext(0))
(* integer passed_mfactor = "m"; *)
 M1 (net10, net4, \gnd! , \gnd! );

endmodule
`noworklib
`noview
