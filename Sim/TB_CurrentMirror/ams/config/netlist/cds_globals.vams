// Verilog-AMS cds_globals module for top-level cell:
//    Stimulator_TestBench/TB_CurrentMirror.
// Generated by ADE.
// Cadence Design Systems, Inc.

// This is an autoGenerated file, any changes done to this file may get lost.

`include "disciplines.vams"
`include "userDisciplines.vams"

module cds_globals;

// Global Signals
   electrical \gnd! ;
   ground \gnd! ;
   wire \vdde! ;
   wire \vdd3! ;

// Design Variables
   dynamicparam real b00 = 2'b00;
   dynamicparam real b01001 = 5'b01001;
   dynamicparam real W = 60u;
   dynamicparam real Wp = 30u;

endmodule
