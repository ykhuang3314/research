// AMS netlist generated by the AMS Unified netlister
// IC subversion:  IC6.1.8-64b.500.7
// Xcelium version: 18.03-s018
// Copyright(C) 2005-2009, Cadence Design Systems, Inc
// User: ykhuang Pid: 9799
// Design library name: EMG_TestBench
// Design cell name: TB_EMG_w_SwitchArray
// Design view name: config
// Solver: Spectre

`include "disciplines.vams"
`include "userDisciplines.vams"
// HDL file - BioZ_EMG_Model, BioZ_EMG_SwitchArray16, verilogams.
// HDL file - EMG_Model, Digital_Stimuli_EMG_V2, functional.
// HDL file - EMG_Model, Signal_Gen, verilogams.
// HDL file - EMG_Model, ADC_EMG, verilogams.
// HDL file - EMG_Model, ANA_MUX_EMG, verilogams.
// HDL file - EMG_Model, IA_EMG_Ideal, verilogams.
// HDL file - EMG_Model, PGA_EMG, verilogams.
// HDL file - EMG_Model, BPF_EMG, verilogams.
// HDL file - EMG_Model, DAC_EMG, verilogams.
// Library - EMG_TestBench, Cell - TB_EMG_w_SwitchArray, View - schematic
// LAST TIME SAVED: Feb 22 15:04:12 2021
// NETLIST TIME: Feb 22 15:06:26 2021

`worklib EMG_TestBench
`view schematic

`timescale 1ns / 1ps
(* cds_ams_schematic *)

module TB_EMG_w_SwitchArray ( );
wire [2:0] SenseMode;
wire [1:0] Col;
wire [2:0] EMG_GAIN_SEL;
wire [3:0] EMG_CH_SEL;
wire [1:0] Row;
wire [11:0] EMG_ADC_DOUT;
wire vdda;
wire EMG_ADC_CLK;
wire OUT_DAC;
wire EMG_ADC_VrefL;
wire EMG_ADC_VrefH;
wire EMG_ADC_START;
wire EMG_ADC_EN;
wire EMG_Ch16;
wire EMG_Ch15;
wire EMG_Ch14;
wire EMG_Ch13;
wire EMG_Ch12;
wire EMG_Ch11;
wire EMG_Ch10;
wire EMG_Ch9;
wire EMG_Ch8;
wire EMG_Ch7;
wire EMG_Ch6;
wire EMG_Ch5;
wire EMG_Ch4;
wire EMG_Ch3;
wire EMG_Ch2;
wire EMG_Ch1;
wire EMG_MUX_CLK;
wire EMG_ADC_EOC;
wire vsub;
wire vssa;
wire Ibias;
wire vssd;
wire vddd;
wire E33;
wire E32;
wire E31;
wire E30;
wire E23;
wire E22;
wire E21;
wire E20;
wire E13;
wire E12;
wire E11;
wire E10;
wire E03;
wire E02;
wire E01;
wire E00;
wire net1;
wire Dir;
wire Vn_bioz;
wire Vp_bioz;
wire IoutN_bioz;
wire IoutP_bioz;
DAC_EMG #(.thresh(0.9)) I78 (.Vout( OUT_DAC ), .Clk( EMG_ADC_CLK ), .Din( EMG_ADC_DOUT ), .Vdda( vdda ), .Vssa(cds_globals.\gnd! ));
MultiCH_16_EMG I9 (.Vddd( vddd ), .Vssd( vssd ), .Ibias( Ibias ), .Vdda( vdda ), .Vssa( vssa ), .Vsub( vsub ), .Dout( EMG_ADC_DOUT[11:0] ), .EoC_ADC( EMG_ADC_EOC ), .CH_Sel( EMG_CH_SEL[3:0] ), .CLK_ADC( EMG_ADC_CLK ), .CLK_MUX( EMG_MUX_CLK ), .E1( EMG_Ch1 ), .E2( EMG_Ch2 ), .E3( EMG_Ch3 ), .E4( EMG_Ch4 ), .E5( EMG_Ch5 ), .E6( EMG_Ch6 ), .E7( EMG_Ch7 ), .E8( EMG_Ch8 ), .E9( EMG_Ch9 ), .E10( EMG_Ch10 ), .E11( EMG_Ch11 ), .E12( EMG_Ch12 ), .E13( EMG_Ch13 ), .E14( EMG_Ch14 ), .E15( EMG_Ch15 ), .E16( EMG_Ch16 ), .En_ADC( EMG_ADC_EN ), .Gain_Sel( EMG_GAIN_SEL[2:0] ), .Start_ADC( EMG_ADC_START ), .Vref(cds_globals.\gnd! ), .VrefH_ADC( EMG_ADC_VrefH ), .VrefL_ADC( EMG_ADC_VrefL ));
Signal_Gen I3 (.Vdda( vdda ), .Vssa( vssa ), .V1( E00 ), .V2( E01 ), .V3( E02 ), .V4( E03 ), .V5( E10 ), .V6( E11 ), .V7( E12 ), .V8( E13 ), .V9( E20 ), .V10( E21 ), .V11( E22 ), .V12( E23 ), .V13( E30 ), .V14( E31 ), .V15( E32 ), .V16( E33 ));
Digital_Stimuli_EMG_V2 I0 (.GAIN_EMG( EMG_GAIN_SEL ), .CH_SEL_EMG( EMG_CH_SEL ), .CLK_EMG( EMG_ADC_CLK ), .EN_ADC_EMG( EMG_ADC_EN ), .MUX_CLK_EMG( EMG_MUX_CLK ), .START_EMG( EMG_ADC_START ), .Enable( net1 ), .RESET(cds_globals.\gnd! ));
BioZ_EMG_SwitchArray16 I17 (.SenseMode( SenseMode ), .EMG_Ch16( EMG_Ch16 ), .EMG_Ch15( EMG_Ch15 ), .EMG_Ch14( EMG_Ch14 ), .EMG_Ch13( EMG_Ch13 ), .EMG_Ch12( EMG_Ch12 ), .EMG_Ch11( EMG_Ch11 ), .EMG_Ch10( EMG_Ch10 ), .EMG_Ch9( EMG_Ch9 ), .EMG_Ch8( EMG_Ch8 ), .EMG_Ch7( EMG_Ch7 ), .EMG_Ch6( EMG_Ch6 ), .EMG_Ch5( EMG_Ch5 ), .EMG_Ch4( EMG_Ch4 ), .EMG_Ch3( EMG_Ch3 ), .EMG_Ch2( EMG_Ch2 ), .EMG_Ch1( EMG_Ch1 ), .BI_Ip( IoutP_bioz ), .BI_In( IoutN_bioz ), .Vdda( vdda ), .Vsub( vsub ), .Vddd( vddd ), .Vssa( vssa ), .Vssd( vssd ), .Row( Row ), .E33( E33 ), .E32( E32 ), .E31( E31 ), .E30( E30 ), .E23( E23 ), .E22( E22 ), .E21( E21 ), .E20( E20 ), .E13( E13 ), .E12( E12 ), .E11( E11 ), .E10( E10 ), .E03( E03 ), .E02( E02 ), .E01( E01 ), .Col( Col ), .BI_Vp( Vp_bioz ), .BI_Vn( Vn_bioz ), .E00( E00 ), .Dir( Dir ));
vsource #(.dc(0), .type("dc")) V9 (SenseMode[2], cds_globals.\gnd! );
vsource #(.dc(0), .type("dc")) V7 (SenseMode[0], cds_globals.\gnd! );
vsource #(.dc(0), .type("dc")) V6 (SenseMode[1], cds_globals.\gnd! );
vsource #(.dc(0), .type("dc")) V35 (Col[0], cds_globals.\gnd! );
vsource #(.dc(0), .type("dc")) V34 (Col[1], cds_globals.\gnd! );
vsource #(.dc(0), .type("dc")) V33 (Row[0], cds_globals.\gnd! );
vsource #(.dc(0), .type("dc")) V32 (Row[1], cds_globals.\gnd! );
vsource #(.dc(0), .type("dc")) V31 (Dir, cds_globals.\gnd! );
vsource #(.dc(0), .type("dc")) V4 (EMG_ADC_VrefL, cds_globals.\gnd! );
vsource #(.dc(1.5), .type("dc")) V1 (EMG_ADC_VrefH, cds_globals.\gnd! );
vsource #(.dc(0), .type("dc")) V11 (vssd, cds_globals.\gnd! );
vsource #(.dc(0), .type("dc")) V12 (vsub, cds_globals.\gnd! );
vsource #(.dc(0), .type("dc")) V8 (vssa, cds_globals.\gnd! );
vsource #(.dc(1.8), .type("dc")) V3 (vddd, cds_globals.\gnd! );
vsource #(.dc(1.8), .type("dc")) V2 (vdda, cds_globals.\gnd! );
vsource #(.type("pwl"), .wave({"0", "0", "1e-05", "1.8"})) V5 (net1, cds_globals.\gnd! );

endmodule
// Library - EMG_Model, Cell - AFE_EMG, View - schematic
// LAST TIME SAVED: Feb  9 12:37:09 2021
// NETLIST TIME: Feb 22 15:06:26 2021

`worklib EMG_Model
`view schematic

`timescale 1ns / 1ps
(* cds_ams_schematic *)

module AFE_EMG (Vout, Ibias, Vdda, Vddd, Vssa, Vssd, Vsub, Gain_Sel, Vinn, Vinp);
output  Vout;
input  Vinn, Vinp;
inout  Ibias, Vdda, Vddd, Vssa, Vssd, Vsub;
input [2:0] Gain_Sel;
wire Voutp_IA;
wire Voutn_IA;
wire Voutp_BPF;
wire Voutn_BPF;
BPF_EMG I1 (.Ibias( Ibias ), .Vdda( Vdda ), .Vssa( Vssa ), .Vsub( Vsub ), .Voutn( Voutn_BPF ), .Voutp( Voutp_BPF ), .Vinn( Voutn_IA ), .Vinp( Voutp_IA ));
PGA_EMG I2 (.Vddd( Vddd ), .Vssd( Vssd ), .Ibias( Ibias ), .Vdda( Vdda ), .Vssa( Vssa ), .Vsub( Vsub ), .Vout( Vout ), .Gain_Sel( Gain_Sel ), .Vinn( Voutn_BPF ), .Vinp( Voutp_BPF ));
IA_EMG_Ideal I0 (.Ibias( Ibias ), .Vdda( Vdda ), .Vssa( Vssa ), .Vsub( Vsub ), .Voutn( Voutn_IA ), .Voutp( Voutp_IA ), .Vinn( Vinn ), .Vinp( Vinp ));

endmodule
// Library - EMG_Model, Cell - MultiCH_16_EMG, View - schematic
// LAST TIME SAVED: Feb  9 13:18:29 2021
// NETLIST TIME: Feb 22 15:06:26 2021

`worklib EMG_Model
`view schematic

`timescale 1ns / 1ps
(* cds_ams_schematic *)

module MultiCH_16_EMG (Dout, EoC_ADC, Ibias, Vdda, Vddd, Vssa, Vssd, Vsub, CH_Sel, CLK_ADC, CLK_MUX, E1, E2, E3, E4, E5, E6, E7, E8, E9, E10, E11, E12, E13, E14, E15, E16, En_ADC, Gain_Sel, Start_ADC, Vref, VrefH_ADC, VrefL_ADC);
output  EoC_ADC;
input  CLK_ADC, CLK_MUX, E1, E2, E3, E4, E5, E6, E7, E8, E9, E10, E11, E12, E13, E14, E15, E16, En_ADC, Start_ADC, Vref, VrefH_ADC, VrefL_ADC;
inout  Ibias, Vdda, Vddd, Vssa, Vssd, Vsub;
output [11:0] Dout;
input [2:0] Gain_Sel;
input [3:0] CH_Sel;
wire Vout_CH16;
wire Vout_CH2;
wire Vout_CH13;
wire Vout_CH1;
wire Vout_CH14;
wire Vout_CH10;
wire Vout_CH5;
wire Vout_CH11;
wire Vout_CH7;
wire Vout_CH9;
wire Vout_CH8;
wire Vout_CH4;
wire Vout_CH6;
wire Vout_CH3;
wire Vout_CH15;
wire Vout_CH12;
wire Vin_ADC;
AFE_EMG I35 (.Vddd( Vddd ), .Vssd( Vssd ), .Ibias( Ibias ), .Vdda( Vdda ), .Vssa( Vssa ), .Vsub( Vsub ), .Vout( Vout_CH16 ), .Gain_Sel( Gain_Sel[2:0] ), .Vinn( Vref ), .Vinp( E16 ));
AFE_EMG I24 (.Vddd( Vddd ), .Vssd( Vssd ), .Ibias( Ibias ), .Vdda( Vdda ), .Vssa( Vssa ), .Vsub( Vsub ), .Vout( Vout_CH2 ), .Gain_Sel( Gain_Sel[2:0] ), .Vinn( Vref ), .Vinp( E2 ));
AFE_EMG I23 (.Vddd( Vddd ), .Vssd( Vssd ), .Ibias( Ibias ), .Vdda( Vdda ), .Vssa( Vssa ), .Vsub( Vsub ), .Vout( Vout_CH13 ), .Gain_Sel( Gain_Sel[2:0] ), .Vinn( Vref ), .Vinp( E13 ));
AFE_EMG I20 (.Vddd( Vddd ), .Vssd( Vssd ), .Ibias( Ibias ), .Vdda( Vdda ), .Vssa( Vssa ), .Vsub( Vsub ), .Vout( Vout_CH1 ), .Gain_Sel( Gain_Sel[2:0] ), .Vinn( Vref ), .Vinp( E1 ));
AFE_EMG I27 (.Vddd( Vddd ), .Vssd( Vssd ), .Ibias( Ibias ), .Vdda( Vdda ), .Vssa( Vssa ), .Vsub( Vsub ), .Vout( Vout_CH14 ), .Gain_Sel( Gain_Sel[2:0] ), .Vinn( Vref ), .Vinp( E14 ));
AFE_EMG I26 (.Vddd( Vddd ), .Vssd( Vssd ), .Ibias( Ibias ), .Vdda( Vdda ), .Vssa( Vssa ), .Vsub( Vsub ), .Vout( Vout_CH10 ), .Gain_Sel( Gain_Sel[2:0] ), .Vinn( Vref ), .Vinp( E10 ));
AFE_EMG I21 (.Vddd( Vddd ), .Vssd( Vssd ), .Ibias( Ibias ), .Vdda( Vdda ), .Vssa( Vssa ), .Vsub( Vsub ), .Vout( Vout_CH5 ), .Gain_Sel( Gain_Sel[2:0] ), .Vinn( Vref ), .Vinp( E5 ));
AFE_EMG I30 (.Vddd( Vddd ), .Vssd( Vssd ), .Ibias( Ibias ), .Vdda( Vdda ), .Vssa( Vssa ), .Vsub( Vsub ), .Vout( Vout_CH11 ), .Gain_Sel( Gain_Sel[2:0] ), .Vinn( Vref ), .Vinp( E11 ));
AFE_EMG I29 (.Vddd( Vddd ), .Vssd( Vssd ), .Ibias( Ibias ), .Vdda( Vdda ), .Vssa( Vssa ), .Vsub( Vsub ), .Vout( Vout_CH7 ), .Gain_Sel( Gain_Sel[2:0] ), .Vinn( Vref ), .Vinp( E7 ));
AFE_EMG I22 (.Vddd( Vddd ), .Vssd( Vssd ), .Ibias( Ibias ), .Vdda( Vdda ), .Vssa( Vssa ), .Vsub( Vsub ), .Vout( Vout_CH9 ), .Gain_Sel( Gain_Sel[2:0] ), .Vinn( Vref ), .Vinp( E9 ));
AFE_EMG I33 (.Vddd( Vddd ), .Vssd( Vssd ), .Ibias( Ibias ), .Vdda( Vdda ), .Vssa( Vssa ), .Vsub( Vsub ), .Vout( Vout_CH8 ), .Gain_Sel( Gain_Sel[2:0] ), .Vinn( Vref ), .Vinp( E8 ));
AFE_EMG I32 (.Vddd( Vddd ), .Vssd( Vssd ), .Ibias( Ibias ), .Vdda( Vdda ), .Vssa( Vssa ), .Vsub( Vsub ), .Vout( Vout_CH4 ), .Gain_Sel( Gain_Sel[2:0] ), .Vinn( Vref ), .Vinp( E4 ));
AFE_EMG I25 (.Vddd( Vddd ), .Vssd( Vssd ), .Ibias( Ibias ), .Vdda( Vdda ), .Vssa( Vssa ), .Vsub( Vsub ), .Vout( Vout_CH6 ), .Gain_Sel( Gain_Sel[2:0] ), .Vinn( Vref ), .Vinp( E6 ));
AFE_EMG I28 (.Vddd( Vddd ), .Vssd( Vssd ), .Ibias( Ibias ), .Vdda( Vdda ), .Vssa( Vssa ), .Vsub( Vsub ), .Vout( Vout_CH3 ), .Gain_Sel( Gain_Sel[2:0] ), .Vinn( Vref ), .Vinp( E3 ));
AFE_EMG I31 (.Vddd( Vddd ), .Vssd( Vssd ), .Ibias( Ibias ), .Vdda( Vdda ), .Vssa( Vssa ), .Vsub( Vsub ), .Vout( Vout_CH15 ), .Gain_Sel( Gain_Sel[2:0] ), .Vinn( Vref ), .Vinp( E15 ));
AFE_EMG I34 (.Vddd( Vddd ), .Vssd( Vssd ), .Ibias( Ibias ), .Vdda( Vdda ), .Vssa( Vssa ), .Vsub( Vsub ), .Vout( Vout_CH12 ), .Gain_Sel( Gain_Sel[2:0] ), .Vinn( Vref ), .Vinp( E12 ));
ANA_MUX_EMG I17 (.Vddd( Vddd ), .Vssd( Vssd ), .Vdda( Vdda ), .Vssa( Vssa ), .Vsub( Vsub ), .Vout( Vin_ADC ), .Clk( CLK_MUX ), .Vin0( Vout_CH1 ), .Vin1( Vout_CH2 ), .Vin2( Vout_CH3 ), .Vin3( Vout_CH4 ), .Vin4( Vout_CH5 ), .Vin5( Vout_CH6 ), .Vin6( Vout_CH7 ), .Vin7( Vout_CH8 ), .Vin8( Vout_CH9 ), .Vin9( Vout_CH10 ), .Vin10( Vout_CH11 ), .Vin11( Vout_CH12 ), .Vin12( Vout_CH13 ), .Vin13( Vout_CH14 ), .Vin14( Vout_CH15 ), .Vin15( Vout_CH16 ), .sel( CH_Sel ));
ADC_EMG I18 (.Vddd( Vddd ), .Vssd( Vssd ), .Ibias( Ibias ), .Vdda( Vdda ), .Vssa( Vssa ), .Vsub( Vsub ), .Dout( Dout ), .EoC( EoC_ADC ), .Clk( CLK_ADC ), .En( En_ADC ), .Start( Start_ADC ), .Vin( Vin_ADC ), .VrefH( VrefH_ADC ), .VrefL( VrefL_ADC ));

endmodule
`noworklib
`noview
