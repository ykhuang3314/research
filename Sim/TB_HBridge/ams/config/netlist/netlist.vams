// AMS netlist generated by the AMS Unified netlister
// IC subversion:  IC6.1.8-64b.500.7
// Xcelium version: 18.03-s018
// Copyright(C) 2005-2009, Cadence Design Systems, Inc
// User: ykhuang Pid: 4981
// Design library name: Stimulator_TestBench
// Design cell name: TB_HBridge
// Design view name: config
// Solver: Spectre

`include "disciplines.vams"
`include "userDisciplines.vams"
// HDL file - Stimulator_Model, Current_Mirror, verilogams.
// HDL file - Stimulator_Model, Current_Source, verilogams.
// HDL file - Stimulator_Model, Digital_Stimulus_ST_V2, functional.
// Library - Stimulator_IMP, Cell - INV3_ST, View - schematic
// LAST TIME SAVED: Mar  3 15:32:31 2021
// NETLIST TIME: Mar 15 15:29:40 2021

`worklib Stimulator_IMP
`view schematic

`timescale 1ns / 1ps
(* cds_ams_schematic *)

module INV3_ST (out, vdd3, vss, in);
output  out;
input  in;
inout  vdd3, vss;
parameter W=2e-06 ;
pe3 #(.w(2*W), .l(3e-07), .as(4.8e-07*(2*W)), .ad(4.8e-07*(2*W)), .ps(1*2*(4.8e-07+(2*W))), .pd(2*(4.8e-07+(2*W))), .nrs(2.7e-07/(2*W)), .nrd(2.7e-07/(2*W)), .m((1)*(1)), .par1((1)*(1)))
(* integer passed_mfactor = "m"; *)
 M1 (out, in, vdd3, vdd3);
ne3 #(.w(W), .l(3.5e-07), .as(4.8e-07*(W)), .ad(4.8e-07*(W)), .ps(1*2*(4.8e-07+(W))), .pd(2*(4.8e-07+(W))), .nrs(2.7e-07/(W)), .nrd(2.7e-07/(W)), .m((1)*(1)), .par1((1)*(1)), .xf_subext(0))
(* integer passed_mfactor = "m"; *)
 M0 (out, in, vss, vss);

endmodule
// Library - Stimulator_IMP, Cell - INV10_ST, View - schematic
// LAST TIME SAVED: Mar  5 11:37:52 2021
// NETLIST TIME: Mar 15 15:29:40 2021

`worklib Stimulator_IMP
`view schematic

`timescale 1ns / 1ps
(* cds_ams_schematic *)

module INV10_ST (out, vdd10, vss, in);
output  out;
input  in;
inout  vdd10, vss;
parameter W=5e-06 ;
nmma_bjt #(.w(W), .l(2.9e-06), .as(1.85e-06*((W)+8.6e-07)), .ad(1.85e-06*((W)+8.6e-07)), .ps(1*2*(1.85e-06+(W)+8.6e-07)), .pd(2*(1.85e-06+(W)+8.6e-07)), .nrs(6e-07/(W)), .nrd(6e-07/(W)), .m((1)*(1)), .par1((1)*(1)), .xf_subext(0))
(* integer passed_mfactor = "m"; *)
 M0 (out, in, vss, vss);
pmma_bjt #(.w(2*W), .l(2.9e-06), .as(1.85e-06*((2*W)+8.6e-07)), .ad(1.85e-06*((2*W)+8.6e-07)), .ps(1*2*(1.85e-06+(2*W)+8.6e-07)), .pd(2*(1.85e-06+(2*W)+8.6e-07)), .nrs(6e-07/(2*W)), .nrd(6e-07/(2*W)), .m((1)*(1)), .par1((1)*(1)))
(* integer passed_mfactor = "m"; *)
 M1 (out, in, vdd10, vdd10, vss);

endmodule
// Library - Stimulator_IMP, Cell - LS_LowSide_ST, View - schematic
// LAST TIME SAVED: Mar  9 10:11:42 2021
// NETLIST TIME: Mar 15 15:29:40 2021

`worklib Stimulator_IMP
`view schematic

`timescale 1ns / 1ps
(* cds_ams_schematic *)

module LS_LowSide_ST (out, outn, vdd3, vdd10, vss, in);
output  out, outn;
input  in;
inout  vdd3, vdd10, vss;
wire IN3;
wire IN3_n;
wire outn_LS;
wire out_LS;
INV3_ST #(.W(2e-06)) I8 (.vss( vss ), .vdd3( vdd3 ), .out( IN3_n ), .in( IN3 ));
INV3_ST #(.W(2e-06)) I1 (.vss( vss ), .vdd3( vdd3 ), .out( IN3 ), .in( in ));
INV10_ST #(.W(5e-06)) I11 (.vss( vss ), .vdd10( vdd10 ), .out( out ), .in( outn_LS ));
INV10_ST #(.W(5e-06)) I12 (.vss( vss ), .vdd10( vdd10 ), .out( outn ), .in( out_LS ));
pmma_bjt #(.w(5e-06), .l(2.9e-06), .as(1.0841e-11), .ad(1.0841e-11), .ps(1.542e-05), .pd(1.542e-05), .nrs(0.12), .nrd(0.12), .m((1)*(1)), .par1((1)*(1)))
(* integer passed_mfactor = "m"; *)
 M3 (out_LS, outn_LS, vdd10, vdd10, cds_globals.\gnd! );
pmma_bjt #(.w(5e-06), .l(2.9e-06), .as(1.0841e-11), .ad(1.0841e-11), .ps(1.542e-05), .pd(1.542e-05), .nrs(0.12), .nrd(0.12), .m((1)*(1)), .par1((1)*(1)))
(* integer passed_mfactor = "m"; *)
 M2 (outn_LS, out_LS, vdd10, vdd10, cds_globals.\gnd! );
nmma_bjt #(.w(1.5e-05), .l(2.9e-06), .as(2.9341e-11), .ad(2.9341e-11), .ps(3.542e-05), .pd(3.542e-05), .nrs(0.04), .nrd(0.04), .m((1)*(1)), .par1((1)*(1)), .xf_subext(0))
(* integer passed_mfactor = "m"; *)
 M8 (out_LS, IN3, vss, vss);
nmma_bjt #(.w(1.5e-05), .l(2.9e-06), .as(2.9341e-11), .ad(2.9341e-11), .ps(3.542e-05), .pd(3.542e-05), .nrs(0.04), .nrd(0.04), .m((1)*(1)), .par1((1)*(1)), .xf_subext(0))
(* integer passed_mfactor = "m"; *)
 M9 (outn_LS, IN3_n, vss, vss);

endmodule
// Library - Stimulator_IMP, Cell - LS_HighSide_V2_ST, View - schematic
// LAST TIME SAVED: Mar  9 10:22:37 2021
// NETLIST TIME: Mar 15 15:29:40 2021

`worklib Stimulator_IMP
`view schematic

`timescale 1ns / 1ps
(* cds_ams_schematic *)

module LS_HighSide_V2_ST (out, outn, vdd3, vdd10, vddh, vss, vssh, in);
output  out, outn;
input  in;
inout  vdd3, vdd10, vddh, vss, vssh;
wire in_shifted;
wire inn_shifted;
wire out_ls;
wire outn_ls;
LS_LowSide_ST I0 (.outn( inn_shifted ), .vss( vss ), .vdd3( vdd3 ), .vdd10( vdd10 ), .out( in_shifted ), .in( in ));
INV10_ST #(.W(5e-06)) I7 (.vss( vssh ), .vdd10( vddh ), .out( out ), .in( out_ls ));
INV10_ST #(.W(5e-06)) I8 (.vss( vssh ), .vdd10( vddh ), .out( outn ), .in( outn_ls ));
nedia #(.w(1e-05), .l(1.25e-06), .m((1)*(1)), .par1((1)*(1)), .extlay(0), .xf_subext(0))
(* integer passed_mfactor = "m"; *)
 M5 (outn_ls, vssh, net26, vss);
nedia #(.w(1e-05), .l(1.25e-06), .m((1)*(1)), .par1((1)*(1)), .extlay(0), .xf_subext(0))
(* integer passed_mfactor = "m"; *)
 M4 (out_ls, vssh, net026, vss);
nedia #(.w(1e-05), .l(1.25e-06), .m((1)*(2)), .par1((1)*(2)), .extlay(0), .xf_subext(0))
(* integer passed_mfactor = "m"; *)
 M1 (net026, inn_shifted, vss, vss);
nedia #(.w(1e-05), .l(1.25e-06), .m((1)*(2)), .par1((1)*(2)), .extlay(0), .xf_subext(0))
(* integer passed_mfactor = "m"; *)
 M0 (net26, in_shifted, vss, vss);
pmma_bjt #(.w(5e-06), .l(2.9e-06), .as(1.0841e-11), .ad(1.0841e-11), .ps(1.542e-05), .pd(1.542e-05), .nrs(0.12), .nrd(0.12), .m((1)*(1)), .par1((1)*(1)))
(* integer passed_mfactor = "m"; *)
 M2 (out_ls, outn_ls, vddh, vddh, vss);
pmma_bjt #(.w(5e-06), .l(2.9e-06), .as(1.0841e-11), .ad(1.0841e-11), .ps(1.542e-05), .pd(1.542e-05), .nrs(0.12), .nrd(0.12), .m((1)*(1)), .par1((1)*(1)))
(* integer passed_mfactor = "m"; *)
 M3 (outn_ls, out_ls, vddh, vddh, vss);
nmma_bjt #(.w(5e-06), .l(2.9e-06), .as(1.0841e-11), .ad(1.0841e-11), .ps(1.542e-05), .pd(1.542e-05), .nrs(0.12), .nrd(0.12), .m((1)*(1)), .par1((1)*(1)), .xf_subext(0))
(* integer passed_mfactor = "m"; *)
 M7 (outn_ls, vssh, vssh, vssh);
nmma_bjt #(.w(5e-06), .l(2.9e-06), .as(1.0841e-11), .ad(1.0841e-11), .ps(1.542e-05), .pd(1.542e-05), .nrs(0.12), .nrd(0.12), .m((1)*(1)), .par1((1)*(1)), .xf_subext(0))
(* integer passed_mfactor = "m"; *)
 M6 (out_ls, vssh, vssh, vssh);

endmodule
// Library - Stimulator_TestBench, Cell - TB_HBridge, View - schematic
// LAST TIME SAVED: Mar 15 15:29:15 2021
// NETLIST TIME: Mar 15 15:29:40 2021

`worklib Stimulator_TestBench
`view schematic

`timescale 1ns / 1ps
(* cds_ams_schematic *)

module TB_HBridge ( );
wire [4:0] MAG_ST;
wire [1:0] CH_SEL_U_ST;
wire [1:0] CH_SEL_D_ST;
wire CAT_ST;
wire net20;
wire CtrlHS_R;
wire vdd3;
wire vdd10;
wire vssh;
wire vddh;
wire vssa;
wire ANO_ST;
wire net21;
wire CtrlHS_L;
wire CtrlLS_L;
wire net19;
wire CtrlLS_R;
wire net16;
wire net10;
wire enable;
wire net9;
wire EN_ST;
wire DIS_ST;
wire Iout_dac;
wire vdda;
wire net11;
wire vddd;
wire vssd;
wire Ist;
LS_HighSide_V2_ST I19 (.vss( vssa ), .vddh( vddh ), .vssh( vssh ), .vdd10( vdd10 ), .vdd3( vdd3 ), .out( CtrlHS_R ), .outn( net20 ), .in( CAT_ST ));
LS_HighSide_V2_ST I0 (.vss( vssa ), .vddh( vddh ), .vssh( vssh ), .vdd10( vdd10 ), .vdd3( vdd3 ), .out( CtrlHS_L ), .outn( net21 ), .in( ANO_ST ));
LS_LowSide_ST I24 (.outn( net19 ), .vss( vssa ), .vdd3( vdd3 ), .vdd10( vdd10 ), .out( CtrlLS_L ), .in( CAT_ST ));
LS_LowSide_ST I1 (.outn( net16 ), .vss( vssa ), .vdd3( vdd3 ), .vdd10( vdd10 ), .out( CtrlLS_R ), .in( ANO_ST ));
Digital_Stimulus_ST_V2 #(.MAG(5'b11111), .num_of_ch(1)) I7 (.CH_SEL_D_ST( CH_SEL_D_ST ), .ANO_ST( ANO_ST ), .CAT_ST( CAT_ST ), .CH_SEL_U_ST( CH_SEL_U_ST ), .DIS_ST( DIS_ST ), .EN_ST( EN_ST ), .MAG_ST( MAG_ST ), .ch_sweeping( net9 ), .enable( enable ), .ramping( net10 ));
Current_Source I3 (.EN( EN_ST ), .Vssd( vssd ), .Vddd( vddd ), .Ibias( net11 ), .Vdda( vdda ), .Vssa( vssa ), .Ioutn( Iout_dac ), .Ioutp( vdda ), .Mag( MAG_ST ));
Current_Mirror I10 (.ANO( ANO_ST ), .CAT( CAT_ST ), .Iref( Iout_dac ), .EN( EN_ST ), .Iout( Ist ), .Vdda( vdda ), .Vssa( vssa ));
vsource #(.type("pwl"), .wave({"0", "0", "1e-05", "1.8"})) V0 (enable, cds_globals.\gnd! );
ped #(.w(4e-05), .l(9.4e-07), .m((1)*(20)), .par1((1)*(20)), .extlay(0), .xf_subext(0))
(* integer passed_mfactor = "m"; *)
 M2 (net7, CtrlHS_R, vddh, cds_globals.\gnd! );
ped #(.w(4e-05), .l(9.4e-07), .m((1)*(20)), .par1((1)*(20)), .extlay(0), .xf_subext(0))
(* integer passed_mfactor = "m"; *)
 M0 (net5, CtrlHS_L, vddh, cds_globals.\gnd! );
nedia #(.w(2e-05), .l(1.25e-06), .m((1)*(20)), .par1((1)*(20)), .extlay(0), .xf_subext(0))
(* integer passed_mfactor = "m"; *)
 M3 (net7, CtrlLS_R, Ist, cds_globals.\gnd! );
nedia #(.w(2e-05), .l(1.25e-06), .m((1)*(20)), .par1((1)*(20)), .extlay(0), .xf_subext(0))
(* integer passed_mfactor = "m"; *)
 M1 (net5, CtrlLS_L, Ist, cds_globals.\gnd! );
resistor #(.r(1000)) R0 (net5, net7);
isource #(.dc(1e-05), .type("dc")) I9 (vdda, net11);
vsource #(.dc(0), .type("dc")) V8 (vssa, cds_globals.\gnd! );
vsource #(.dc(0), .type("dc")) V7 (vssd, cds_globals.\gnd! );
vsource #(.dc(1.8), .type("dc")) V6 (vddd, cds_globals.\gnd! );
vsource #(.dc(1.8), .type("dc")) V3 (vdda, cds_globals.\gnd! );
vsource #(.dc(40), .type("dc")) V4 (vddh, cds_globals.\gnd! );
vsource #(.dc(3.3), .type("dc")) V11 (vdd3, cds_globals.\gnd! );
vsource #(.dc(10), .type("dc")) V10 (vdd10, cds_globals.\gnd! );
vsource #(.dc(30), .type("dc")) V9 (vssh, cds_globals.\gnd! );
vsource #(.dc(0), .type("dc")) V5 (vssa, cds_globals.\gnd! );
vsource #(.dc(1.8), .type("dc")) V1 (net10, cds_globals.\gnd! );
vsource #(.dc(0), .type("dc")) V2 (net9, cds_globals.\gnd! );

endmodule
`noworklib
`noview
