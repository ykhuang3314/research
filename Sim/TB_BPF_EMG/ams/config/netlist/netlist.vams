// AMS netlist generated by the AMS Unified netlister
// IC subversion:  IC6.1.8-64b.500.7
// Xcelium version: 18.03-s018
// Copyright(C) 2005-2009, Cadence Design Systems, Inc
// User: ykhuang Pid: 11132
// Design library name: EMG_TestBench
// Design cell name: TB_BPF_EMG
// Design view name: config
// Solver: Spectre

`include "disciplines.vams"
`include "userDisciplines.vams"
// HDL file - EMG_Model, BPF_EMG, verilogams.
// Library - EMG_TestBench, Cell - TB_BPF_EMG, View - schematic
// LAST TIME SAVED: Nov 16 22:21:27 2020
// NETLIST TIME: Nov 16 22:21:45 2020

`worklib EMG_TestBench
`view schematic

`timescale 1ns / 1ps
(* cds_ams_schematic *)

module TB_BPF_EMG ( );
wire Vsig;
wire net04;
wire net05;
wire Vdda;
wire net5;
BPF_EMG I0 (.Ibias( net5 ), .Vdda( Vdda ), .Vssa(cds_globals.\gnd! ), .Vsub(cds_globals.\gnd! ), .Voutn( net05 ), .Voutp( net04 ), .Vinn(cds_globals.\gnd! ), .Vinp( Vsig ));
vsource #(.mag(1), .type("sine")) V0 (Vsig, cds_globals.\gnd! );
vsource #(.dc(1.8), .type("dc")) V1 (Vdda, cds_globals.\gnd! );
isource #(.dc(1e-05), .type("dc")) I1 (Vdda, net5);
vcvs #(.gain(1)) E0 (Vout, cds_globals.\gnd! , net04, net05);

endmodule
`noworklib
`noview
