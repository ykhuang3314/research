// AMS netlist generated by the AMS Unified netlister
// IC subversion:  IC6.1.8-64b.500.7
// Xcelium version: 18.03-s018
// Copyright(C) 2005-2009, Cadence Design Systems, Inc
// User: ykhuang Pid: 18573
// Design library name: EMG_202009
// Design cell name: TB_Mux4
// Design view name: config
// Solver: Spectre

`include "disciplines.vams"
`include "userDisciplines.vams"
// HDL file - EMG_202009, Digital_Stimuli_Mux4, functional.
// HDL file - EMG_202009, AnalogMux_4, verilogams.
// Library - EMG_202009, Cell - TB_Mux4, View - schematic
// LAST TIME SAVED: Sep 23 14:07:39 2020
// NETLIST TIME: Sep 23 14:09:44 2020

`worklib EMG_202009
`view schematic

`timescale 1ns / 1ps
(* cds_ams_schematic *)

module TB_Mux4 ( );
wire [1:0] sel;
wire Vin3;
wire Vin2;
wire Vin1;
wire Vin0;
wire Vdda;
wire Vout;
AnalogMux_4 I0 (.Vout( Vout ), .Vdda( Vdda ), .Vin0( Vin0 ), .Vin1( Vin1 ), .Vin2( Vin2 ), .Vin3( Vin3 ), .Vssa(cds_globals.\gnd! ), .sel( sel ));
Digital_Stimuli_Mux4 I4 (.Sel_Mux4( sel ));
vsource #(.type("pulse"), .delay(0.05), .val0(0), .val1(1.8), .period(0.1), .rise(1e-11), .fall(1e-11)) V7 (net3, cds_globals.\gnd! );
vsource #(.type("pulse"), .delay(0.025), .val0(0), .val1(1.8), .period(0.05), .rise(1e-11), .fall(1e-11)) V6 (net4, cds_globals.\gnd! );
vsource #(.dc(1.8), .type("dc")) V4 (Vdda, cds_globals.\gnd! );
vsource #(.type("sine"), .freq(50), .ampl(0.06)) V2 (Vin2, cds_globals.\gnd! );
vsource #(.type("sine"), .freq(500), .ampl(0.5)) V1 (Vin1, cds_globals.\gnd! );
vsource #(.type("sine"), .freq(1000), .ampl(0.1)) V0 (Vin0, cds_globals.\gnd! );
vsource #(.type("sine"), .freq(100), .ampl(0.1)) V3 (Vin3, cds_globals.\gnd! );

endmodule
`noworklib
`noview
