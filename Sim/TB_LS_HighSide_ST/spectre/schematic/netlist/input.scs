// Design: Stimulator_TestBench/TB_LS_HighSide_ST
simulator lang=spectre
global 0 vdde! vdd3!
parameters Ibias=10u
include "/pkg/xfab/XKIT/xh018/cadence/v8_0/spectre/v8_0_1/lpmos/config.scs" section=default
include "/pkg/xfab/XKIT/xh018/cadence/v8_0/spectre/v8_0_1/lpmos/param.scs" section=3s
include "/pkg/xfab/XKIT/xh018/cadence/v8_0/spectre/v8_0_1/lpmos/bip.scs" section=tm
include "/pkg/xfab/XKIT/xh018/cadence/v8_0/spectre/v8_0_1/lpmos/cap.scs" section=tm
include "/pkg/xfab/XKIT/xh018/cadence/v8_0/spectre/v8_0_1/lpmos/dio.scs" section=tm
include "/pkg/xfab/XKIT/xh018/cadence/v8_0/spectre/v8_0_1/lpmos/mos.scs" section=tm
include "/pkg/xfab/XKIT/xh018/cadence/v8_0/spectre/v8_0_1/lpmos/photo.scs" section=tm
include "/pkg/xfab/XKIT/xh018/cadence/v8_0/spectre/v8_0_1/lpmos/res.scs" section=tm

// GATES_3V/invrv3/schematic
subckt invrv3 in out inh_ground_gnd inh_power_vdd3
parameters GT_PDW GT_PDL=350.00n sx=4.8e-07 lc=2.7e-07 GT_PUW GT_PUL=300.00n
    MN1 (out in inh_ground_gnd inh_ground_gnd) ne3 w=GT_PDW l=GT_PDL m=(1)*(1)
    MP1 (out in inh_power_vdd3 inh_power_vdd3) pe3 w=GT_PUW l=GT_PUL m=(1)*(1)
ends invrv3

// D_CELLS_3V/IN_3VX1/cmos_sch
subckt IN_3VX1 A Q inh_ground_gnd inh_power_vdd3
    invr_1 (A Q inh_ground_gnd inh_power_vdd3) invrv3 GT_PDW=600.00n GT_PDL=350.00n sx=4.8e-07 lc=2.7e-07 GT_PUW=1.41u GT_PUL=300.00n
ends IN_3VX1

// D_CELLS_M3V/LSHVT18U3VX1/cmos_sch
subckt LSHVT18U3VX1 A Q inh_ground_gnd inh_power_vdd3 inh_power_vdde
    M6 (Q net20 inh_power_vdd3 inh_power_vdd3) pe3 w=1.46u l=300n m=(1)*(1)
    M8 (net4 A inh_power_vdde inh_power_vdd3) pe3 w=1.48u l=300n m=(1)*(1)
    M9 (net20 A net024 inh_power_vdd3) pe3 w=420.0n l=300n m=(1)*(1)
    M0 (net10 net4 net023 inh_power_vdd3) pe3 w=420.0n l=300n m=(1)*(1)
    M2 (net023 net20 inh_power_vdd3 inh_power_vdd3) pe3 w=420.0n l=300n m=(1)*(1)
    M4 (net024 net10 inh_power_vdd3 inh_power_vdd3) pe3 w=420.0n l=300n m=(1)*(1)
    M3 (net20 A inh_ground_gnd inh_ground_gnd) ne3 w=1.31u l=350.0n m=(1)*(1)
    M5 (Q net20 inh_ground_gnd inh_ground_gnd) ne3 w=890.0n l=350.0n m=(1)*(1)
    M7 (net4 A inh_ground_gnd inh_ground_gnd) ne3 w=420.0n l=350.0n m=(1)*(1)
    M1 (net10 net4 inh_ground_gnd inh_ground_gnd) ne3 w=1.31u l=350.0n m=(1)*(1)
ends LSHVT18U3VX1

// Stimulator_IMP/LS_HighSide_V3_ST/schematic
subckt LS_HighSide_V3_ST 0 in out vdd3! vdde! vddh inh_ground_gnd inh_power_vdd3 inh_power_vdde
    R9 (vddh out) resistor r=100k
    R8 (out net10) resistor r=300k
    M13 (net10 inn3v 0 0) nedia_bjt w=10u l=1.25u m=(1)*(2) par1=((1)*(2)) extlay=0 xf_subext=0
    I11 (in3v inn3v inh_ground_gnd inh_power_vdd3) IN_3VX1
    I10 (in in3v inh_ground_gnd inh_power_vdd3 inh_power_vdde) LSHVT18U3VX1
ends LS_HighSide_V3_ST

// Stimulator_TestBench/TB_LS_HighSide_ST/schematic
M13 (net015 inn_3v 0 0) nedia_bjt w=10u l=1.25u m=(1)*(2) par1=((1)*(2)) extlay=0 xf_subext=0
M2 (net8 inn_3v net9 0) nedia_bjt w=10u l=1.25u m=(1)*(3) par1=((1)*(3)) extlay=0 xf_subext=0
I0 (vdde! bias) isource dc=Ibias type=dc
M0 (net9 bias 0 0) ne3 w=2u l=350.0n m=(1)*(10)
M1 (bias bias 0 0) ne3 w=2u l=350.0n m=(1)*(1)
V0 (in 0) vsource type=pulse val0=0 val1=1.8 period=100u delay=50u rise=1p fall=1p width=50u
I11 (in_3v inn_3v 0 vdd3!) IN_3VX1
R9 (vddH net011) resistor r=100k
R8 (net011 net015) resistor r=300k
R1 (vddH net010) resistor r=100k
R4 (net010 net8) resistor r=300k
V3 (vddH 0) vsource dc=40 type=dc
V2 (vdde! 0) vsource dc=1.8 type=dc
V1 (vdd3! 0) vsource dc=3.3 type=dc
I12 (0 in net017 vdd3! vdde! vddH 0 vdd3! vdde!) LS_HighSide_V3_ST
I10 (in in_3v 0 vdd3! vdde!) LSHVT18U3VX1
C0 (net017 0) capacitor c=1p
simulatorOptions options reltol=100e-6 temp=27 homotopy=all limit=delta compatible=spice2
tran tran stop=500u errpreset=conservative
save M13:1
