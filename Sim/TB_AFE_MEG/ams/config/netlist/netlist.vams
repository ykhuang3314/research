// AMS netlist generated by the AMS Unified netlister
// IC subversion:  IC6.1.8-64b.500.7
// Xcelium version: 18.03-s018
// Copyright(C) 2005-2009, Cadence Design Systems, Inc
// User: ykhuang Pid: 11132
// Design library name: EMG_TestBench
// Design cell name: TB_AFE_MEG
// Design view name: config
// Solver: Spectre

`include "disciplines.vams"
`include "userDisciplines.vams"
// HDL file - EMG_Model, IA_EMG, verilogams.
// HDL file - EMG_Model, PGA_EMG, verilogams.
// HDL file - EMG_Model, BPF_EMG, verilogams.
// Library - EMG_TestBench, Cell - TB_AFE_MEG, View - schematic
// LAST TIME SAVED: Nov 16 22:42:46 2020
// NETLIST TIME: Nov 16 22:44:17 2020

`worklib EMG_TestBench
`view schematic

`timescale 1ns / 1ps
(* cds_ams_schematic *)

module TB_AFE_MEG ( );
wire [2:0] Gain_Sel;
wire net8;
wire net7;
wire Vout;
wire vdda;
wire Ibias;
AFE_EMG I0 (.Ibias( Ibias ), .Vdda( vdda ), .Vssa(cds_globals.\gnd! ), .Vsub(cds_globals.\gnd! ), .Vout( Vout ), .Gain_Sel( Gain_Sel[2:0] ), .Vinn( net7 ), .Vinp( net8 ));
vcvs #(.gain(0.5)) E1 (net8, Vin_CM, vsig, cds_globals.\gnd! );
vcvs #(.gain(-0.5)) E0 (net7, Vin_CM, vsig, cds_globals.\gnd! );
vcvs #(.gain(0.001)) E2 (Vemg, cds_globals.\gnd! , Vemg_raw, cds_globals.\gnd! );
vsource #(.type("pwl"), .file("/home/ykhuang/research/Emg_Data/emg_healthy.txt")) V3 (Vemg_raw, cds_globals.\gnd! );
vsource #(.type("sine"), .ampl(0.005), .freq(100)) V2 (vsig, cds_globals.\gnd! );
vsource #(.dc(0), .type("dc")) V6 (Gain_Sel[0], cds_globals.\gnd! );
vsource #(.dc(0), .type("dc")) V5 (Gain_Sel[1], cds_globals.\gnd! );
vsource #(.dc(0), .type("dc")) V4 (Gain_Sel[2], cds_globals.\gnd! );
vsource #(.dc(0), .type("dc")) V1 (Vin_CM, cds_globals.\gnd! );
vsource #(.dc(1.8), .type("dc")) V0 (vdda, cds_globals.\gnd! );
isource #(.dc(1e-05), .type("dc")) I1 (vdda, Ibias);

endmodule
// Library - EMG_Model, Cell - AFE_EMG, View - schematic
// LAST TIME SAVED: Nov 16 22:13:17 2020
// NETLIST TIME: Nov 16 22:44:17 2020

`worklib EMG_Model
`view schematic

`timescale 1ns / 1ps
(* cds_ams_schematic *)

module AFE_EMG (Vout, Ibias, Vdda, Vssa, Vsub, Gain_Sel, Vinn, Vinp);
output  Vout;
input  Vinn, Vinp;
inout  Ibias, Vdda, Vssa, Vsub;
input [2:0] Gain_Sel;
wire net14;
wire net13;
wire net15;
wire net16;
wire vdda;
BPF_EMG I1 (.Ibias( Ibias ), .Vdda( vdda ), .Vssa( Vssa ), .Vsub( Vsub ), .Voutn( net16 ), .Voutp( net15 ), .Vinn( net13 ), .Vinp( net14 ));
PGA_EMG I2 (.Ibias( Ibias ), .Vdda( Vdda ), .Vssa( Vssa ), .Vsub( Vsub ), .Vout( Vout ), .Gain_Sel( Gain_Sel ), .Vinn( net16 ), .Vinp( net15 ));
IA_EMG I0 (.Ibias( Ibias ), .Vdda( vdda ), .Vssa( Vssa ), .Vsub( Vsub ), .Voutn( net13 ), .Voutp( net14 ), .Vinn( Vinn ), .Vinp( Vinp ));

endmodule
`noworklib
`noview
