// AMS netlist generated by the AMS Unified netlister
// IC subversion:  IC6.1.8-64b.500.7
// Xcelium version: 18.03-s018
// Copyright(C) 2005-2009, Cadence Design Systems, Inc
// User: ykhuang Pid: 8748
// Design library name: EMG_202009
// Design cell name: TB_SwitchArray
// Design view name: config
// Solver: Spectre

`include "disciplines.vams"
`include "userDisciplines.vams"
// HDL file - EMG_202009, Counter_Nbit, functional.
// HDL file - EMG_202009, SwitchArray, verilogams.
// Library - EMG_202009, Cell - TB_SwitchArray, View - schematic
// LAST TIME SAVED: Oct 14 14:49:58 2020
// NETLIST TIME: Oct 14 14:51:50 2020

`worklib EMG_202009
`view schematic

`timescale 1ns / 1ps
(* cds_ams_schematic *)

module TB_SwitchArray ( );
wire [2:0] Col;
wire [1:0] Row;
wire Vdda;
wire V_E37;
wire V_E36;
wire V_E35;
wire V_E34;
wire V_E33;
wire V_E32;
wire V_E31;
wire V_E30;
wire V_E27;
wire V_E26;
wire V_E25;
wire V_E24;
wire V_E23;
wire V_E22;
wire V_E21;
wire V_E20;
wire V_E17;
wire V_E16;
wire V_E15;
wire V_E14;
wire V_E13;
wire V_E12;
wire V_E11;
wire V_E10;
wire V_E07;
wire V_E06;
wire V_E05;
wire V_E04;
wire V_E03;
wire V_E02;
wire V_E01;
wire V_E00;
wire net2;
wire net3;
wire net4;
wire net5;
wire net6;
wire net7;
wire net8;
wire net9;
wire net10;
wire net11;
wire net12;
wire net13;
wire net14;
wire net15;
wire net16;
wire net17;
wire net18;
wire net19;
wire net20;
wire net21;
wire net22;
wire net23;
wire net24;
wire net25;
wire net26;
wire net27;
wire net28;
wire net29;
wire net30;
wire net31;
wire net32;
wire net33;
wire BI_Vp;
wire BI_Vn;
wire BI_Ip;
wire BI_In;
wire CLK;
SwitchArray I0 (.Col( Col ), .BI_In( BI_In ), .BI_Ip( BI_Ip ), .BI_Vn( BI_Vn ), .BI_Vp( BI_Vp ), .EMG_Ch1( net33 ), .EMG_Ch2( net32 ), .EMG_Ch3( net31 ), .EMG_Ch4( net30 ), .EMG_Ch5( net29 ), .EMG_Ch6( net28 ), .EMG_Ch7( net27 ), .EMG_Ch8( net26 ), .EMG_Ch9( net25 ), .EMG_Ch10( net24 ), .EMG_Ch11( net23 ), .EMG_Ch12( net22 ), .EMG_Ch13( net21 ), .EMG_Ch14( net20 ), .EMG_Ch15( net19 ), .EMG_Ch16( net18 ), .EMG_Ch17( net17 ), .EMG_Ch18( net16 ), .EMG_Ch19( net15 ), .EMG_Ch20( net14 ), .EMG_Ch21( net13 ), .EMG_Ch22( net12 ), .EMG_Ch23( net11 ), .EMG_Ch24( net10 ), .EMG_Ch25( net9 ), .EMG_Ch26( net8 ), .EMG_Ch27( net7 ), .EMG_Ch28( net6 ), .EMG_Ch29( net5 ), .EMG_Ch30( net4 ), .EMG_Ch31( net3 ), .EMG_Ch32( net2 ), .Dir(cds_globals.\gnd! ), .Dis(cds_globals.\gnd! ), .E00( V_E00 ), .E01( V_E01 ), .E02( V_E02 ), .E03( V_E03 ), .E04( V_E04 ), .E05( V_E05 ), .E06( V_E06 ), .E07( V_E07 ), .E10( V_E10 ), .E11( V_E11 ), .E12( V_E12 ), .E13( V_E13 ), .E14( V_E14 ), .E15( V_E15 ), .E16( V_E16 ), .E17( V_E17 ), .E20( V_E20 ), .E21( V_E21 ), .E22( V_E22 ), .E23( V_E23 ), .E24( V_E24 ), .E25( V_E25 ), .E26( V_E26 ), .E27( V_E27 ), .E30( V_E30 ), .E31( V_E31 ), .E32( V_E32 ), .E33( V_E33 ), .E34( V_E34 ), .E35( V_E35 ), .E36( V_E36 ), .E37( V_E37 ), .Mode(cds_globals.\gnd! ), .Row( Row ), .Vdda( Vdda ), .Vssa(cds_globals.\gnd! ));
Counter_Nbit I38 (.out( Col ), .Clk( CLK ), .Reset(cds_globals.\gnd! ));
vsource #(.dc(0), .type("dc")) V55 (Row[1], cds_globals.\gnd! );
vsource #(.dc(0), .type("dc")) V54 (Row[0], cds_globals.\gnd! );
vsource #(.dc(1.8), .type("dc")) V53 (Vdda, cds_globals.\gnd! );
vsource #(.dc(1.8*(3/8)), .type("dc")) V32 (V_E12, cds_globals.\gnd! );
vsource #(.dc(1.8*(3/8)), .type("dc")) V33 (V_E22, cds_globals.\gnd! );
vsource #(.dc(1.8*(3/8)), .type("dc")) V34 (V_E32, cds_globals.\gnd! );
vsource #(.dc(1.8*(8/8)), .type("dc")) V28 (V_E07, cds_globals.\gnd! );
vsource #(.dc(1.8*(4/8)), .type("dc")) V35 (V_E13, cds_globals.\gnd! );
vsource #(.dc(1.8*(4/8)), .type("dc")) V36 (V_E23, cds_globals.\gnd! );
vsource #(.dc(1.8*(4/8)), .type("dc")) V37 (V_E33, cds_globals.\gnd! );
vsource #(.dc(1.8*(7/8)), .type("dc")) V24 (V_E06, cds_globals.\gnd! );
vsource #(.dc(1.8*(5/8)), .type("dc")) V38 (V_E14, cds_globals.\gnd! );
vsource #(.dc(1.8*(5/8)), .type("dc")) V39 (V_E24, cds_globals.\gnd! );
vsource #(.dc(1.8*(5/8)), .type("dc")) V40 (V_E34, cds_globals.\gnd! );
vsource #(.dc(1.8*(6/8)), .type("dc")) V20 (V_E05, cds_globals.\gnd! );
vsource #(.dc(1.8*(6/8)), .type("dc")) V46 (V_E35, cds_globals.\gnd! );
vsource #(.dc(1.8*(6/8)), .type("dc")) V45 (V_E25, cds_globals.\gnd! );
vsource #(.dc(1.8*(6/8)), .type("dc")) V44 (V_E15, cds_globals.\gnd! );
vsource #(.dc(1.8*(5/8)), .type("dc")) V16 (V_E04, cds_globals.\gnd! );
vsource #(.dc(1.8*(7/8)), .type("dc")) V47 (V_E16, cds_globals.\gnd! );
vsource #(.dc(1.8*(7/8)), .type("dc")) V48 (V_E26, cds_globals.\gnd! );
vsource #(.dc(1.8*(7/8)), .type("dc")) V49 (V_E36, cds_globals.\gnd! );
vsource #(.dc(1.8*(4/8)), .type("dc")) V12 (V_E03, cds_globals.\gnd! );
vsource #(.dc(1.8*(8/8)), .type("dc")) V50 (V_E17, cds_globals.\gnd! );
vsource #(.dc(1.8*(8/8)), .type("dc")) V51 (V_E27, cds_globals.\gnd! );
vsource #(.dc(1.8*(8/8)), .type("dc")) V52 (V_E37, cds_globals.\gnd! );
vsource #(.dc(1.8*(3/8)), .type("dc")) V8 (V_E02, cds_globals.\gnd! );
vsource #(.dc(1.8*(2/8)), .type("dc")) V7 (V_E31, cds_globals.\gnd! );
vsource #(.dc(1.8*(2/8)), .type("dc")) V6 (V_E21, cds_globals.\gnd! );
vsource #(.dc(1.8*(2/8)), .type("dc")) V5 (V_E11, cds_globals.\gnd! );
vsource #(.dc(1.8*(2/8)), .type("dc")) V4 (V_E01, cds_globals.\gnd! );
vsource #(.dc(1.8*(1/8)), .type("dc")) V3 (V_E30, cds_globals.\gnd! );
vsource #(.dc(1.8*(1/8)), .type("dc")) V2 (V_E20, cds_globals.\gnd! );
vsource #(.dc(1.8*(1/8)), .type("dc")) V1 (V_E10, cds_globals.\gnd! );
vsource #(.dc(1.8*(1/8)), .type("dc")) V0 (V_E00, cds_globals.\gnd! );
vsource #(.type("pulse"), .val0(0), .val1(1.8), .period(2e-05), .delay(1e-05), .rise(1e-12), .fall(1e-12), .width(1e-05)) V9 (CLK, cds_globals.\gnd! );

endmodule
`noworklib
`noview
