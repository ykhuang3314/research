// Design: Stimulator_TestBench/TB_Compliance_voltage
simulator lang=spectre
global 0 vdde! vdd3!
parameters Iref=280u vout=20
include "/pkg/xfab/XKIT/xh018/cadence/v8_0/spectre/v8_0_1/lpmos/config.scs" section=default
include "/pkg/xfab/XKIT/xh018/cadence/v8_0/spectre/v8_0_1/lpmos/param.scs" section=3s
include "/pkg/xfab/XKIT/xh018/cadence/v8_0/spectre/v8_0_1/lpmos/bip.scs" section=tm
include "/pkg/xfab/XKIT/xh018/cadence/v8_0/spectre/v8_0_1/lpmos/cap.scs" section=tm
include "/pkg/xfab/XKIT/xh018/cadence/v8_0/spectre/v8_0_1/lpmos/dio.scs" section=tm
include "/pkg/xfab/XKIT/xh018/cadence/v8_0/spectre/v8_0_1/lpmos/mos.scs" section=tm
include "/pkg/xfab/XKIT/xh018/cadence/v8_0/spectre/v8_0_1/lpmos/photo.scs" section=tm
include "/pkg/xfab/XKIT/xh018/cadence/v8_0/spectre/v8_0_1/lpmos/res.scs" section=tm

// Stimulator_IMP/CurrentMirror_x10_LV/schematic
subckt CurrentMirror_x10_LV Iin Ix10 0
    M26 (Iin Iin 0 0) ne3 w=12.0u l=3u m=(6)*(1)
    M13 (Ix10 Iin 0 0) ne3 w=12.0u l=3u m=(60)*(1)
ends CurrentMirror_x10_LV

// D_CELLS_M3V/LSHVT18U3VX2/cmos_sch
subckt LSHVT18U3VX2 A Q inh_ground_gnd inh_power_vdd3 inh_power_vdde
    M6 (Q net20 inh_power_vdd3 inh_power_vdd3) pe3 w=2.82u l=300n m=(1)*(1)
    M8 (net4 A inh_power_vdde inh_power_vdd3) pe3 w=1.47u l=300n m=(1)*(1)
    M9 (net20 A net024 inh_power_vdd3) pe3 w=420.0n l=300n m=(1)*(1)
    M0 (net10 net4 net023 inh_power_vdd3) pe3 w=420.0n l=300n m=(1)*(1)
    M2 (net023 net20 inh_power_vdd3 inh_power_vdd3) pe3 w=420.0n l=300n m=(1)*(1)
    M4 (net024 net10 inh_power_vdd3 inh_power_vdd3) pe3 w=420.0n l=300n m=(1)*(1)
    M3 (net20 A inh_ground_gnd inh_ground_gnd) ne3 w=1.31u l=350.0n m=(1)*(1)
    M5 (Q net20 inh_ground_gnd inh_ground_gnd) ne3 w=1.78u l=350.0n m=(1)*(1)
    M7 (net4 A inh_ground_gnd inh_ground_gnd) ne3 w=420.0n l=350.0n m=(1)*(1)
    M1 (net10 net4 inh_ground_gnd inh_ground_gnd) ne3 w=1.31u l=350.0n m=(1)*(1)
ends LSHVT18U3VX2

// Stimulator_TestBench/TB_Compliance_voltage/schematic
V3 (net84 0) vsource dc=vout type=dc
V2 (vdd3! 0) vsource dc=3.3 type=dc
V1 (vddh 0) vsource dc=40 type=dc
V0 (enable 0) vsource dc=1.8 type=dc
R0 (en_3v net85) rpp1k1 l=111.22u w=2u m=1 par1=(1)
R3 (net85 0) rpp1k1 l=111.22u w=2u m=1 par1=(1)
R2 (vdd3! 0) rpp1k1 l=369.98u w=2u m=1 par1=(1)
C5 (vddh Vmid) csft5a area=6.3936e-11 perimeter=33.72u m=15 par1=(15)
C1 (Vmid 0) csft5a area=6.3936e-11 perimeter=33.72u m=45 par1=(45)
I0 (net86 Iout_LV 0) CurrentMirror_x10_LV
M14 (Iout2 Iout2 VG1 0) nedia_bjt w=40u l=1.25u m=(1)*(1) par1=((1)*(1)) extlay=0 xf_subext=0
M16 (Bias2 en_3v Iout_LV 0) nedia_bjt w=60u l=1.25u m=(1)*(5) par1=((1)*(5)) extlay=0 xf_subext=0
M8 (Iout1 Iout1 VB 0) nedia_bjt w=80u l=1.25u m=(1)*(1) par1=((1)*(1)) extlay=0 xf_subext=0
M5 (VG1 VB VD_M4 0) nedia_bjt w=80u l=1.25u m=(1)*(1) par1=((1)*(1)) extlay=0 xf_subext=0
M0 (net84 VB VD_M3 0) nedia_bjt w=80u l=1.25u m=(10)*(1) par1=((10)*(1)) extlay=0 xf_subext=0
M7 (VB Iout1 net71 0) nedia_bjt w=35.0u l=1.25u m=(1)*(1) par1=((1)*(1)) extlay=0 xf_subext=0
M15 (Vmid vdd3! 0 0) nedia_bjt w=10u l=1.25u m=(1)*(1) par1=((1)*(1)) extlay=0 xf_subext=0
M6 (net71 net71 0 0) nedia_bjt w=80u l=1.25u m=(1)*(1) par1=((1)*(1)) extlay=0 xf_subext=0
M4 (VD_M4 VG1 0 0) nedia_bjt w=80u l=1.25u m=(1)*(1) par1=((1)*(1)) extlay=0 xf_subext=0
M3 (VD_M3 VG1 0 0) nedia_bjt w=80u l=1.25u m=(10)*(1) par1=((10)*(1)) extlay=0 xf_subext=0
M17 (Iout_LV Vmid 0 0) nedia_bjt w=10u l=1.25u m=(1)*(1) par1=((1)*(1)) extlay=0 xf_subext=0
I17 (enable en_3v 0 vdd3! vdde!) LSHVT18U3VX2
M11 (VD_M11 Bias1 vddh 0) ped_bjt w=30u l=940.0n m=(1)*(1) par1=((1)*(1)) extlay=0 xf_subext=0
M1 (VD_M1 Bias1 vddh 0) ped_bjt w=30u l=940.0n m=(1)*(1) par1=((1)*(1)) extlay=0 xf_subext=0
M2 (Bias1 Bias1 vddh 0) ped_bjt w=30u l=940.0n m=(1)*(1) par1=((1)*(1)) extlay=0 xf_subext=0
M12 (Iout2 Bias2 VD_M11 0) ped_bjt w=30u l=940.0n m=(1)*(1) par1=((1)*(1)) extlay=0 xf_subext=0
M10 (Iout1 Bias2 VD_M1 0) ped_bjt w=30u l=940.0n m=(1)*(1) par1=((1)*(1)) extlay=0 xf_subext=0
M9 (Bias2 Bias2 Bias1 0) ped_bjt w=30u l=940.0n m=(1)*(1) par1=((1)*(1)) extlay=0 xf_subext=0
I2 (vdd3! net86) isource dc=Iref type=dc
simulatorOptions options reltol=100e-6 temp=27 homotopy=all limit=delta compatible=spice2
data paramset {
 Iref
 1e-05
 5e-05
 0.0001
 0.00015
 0.0002
 0.00024
 0.00028
}

sweep1 sweep paramset=data{
dcOp dc
dc dc param=vout start=0 stop=40
}
save M0:1
