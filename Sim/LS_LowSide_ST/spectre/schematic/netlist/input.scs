// Design: Stimulator_IMP/LS_LowSide_ST
simulator lang=spectre
global 0
parameters Wp=5u Wn=10u
include "/pkg/xfab/XKIT/xh018/cadence/v8_0/spectre/v8_0_1/lpmos/config.scs" section=default
include "/pkg/xfab/XKIT/xh018/cadence/v8_0/spectre/v8_0_1/lpmos/param.scs" section=3s
include "/pkg/xfab/XKIT/xh018/cadence/v8_0/spectre/v8_0_1/lpmos/bip.scs" section=tm
include "/pkg/xfab/XKIT/xh018/cadence/v8_0/spectre/v8_0_1/lpmos/cap.scs" section=tm
include "/pkg/xfab/XKIT/xh018/cadence/v8_0/spectre/v8_0_1/lpmos/dio.scs" section=tm
include "/pkg/xfab/XKIT/xh018/cadence/v8_0/spectre/v8_0_1/lpmos/mos.scs" section=tm
include "/pkg/xfab/XKIT/xh018/cadence/v8_0/spectre/v8_0_1/lpmos/photo.scs" section=tm
include "/pkg/xfab/XKIT/xh018/cadence/v8_0/spectre/v8_0_1/lpmos/res.scs" section=tm

// Stimulator_IMP/INV_ST/schematic
subckt INV_ST in out vddd vss
parameters W=2u
    M0 (out in vss vss) ne w=W l=180.0n m=(1)*(1)
    M1 (out in vddd vddd) pe w=W*2 l=180.0n m=(1)*(1)
ends INV_ST

// Stimulator_IMP/INV3_ST/schematic
subckt INV3_ST in out vdd3 vss
parameters W=2u
    M1 (out in vdd3 vdd3) pe3 w=2*W l=300n m=(1)*(1)
    M0 (out in vss vss) ne3 w=W l=350.0n m=(1)*(1)
ends INV3_ST

// Stimulator_IMP/LS_LowSide_ST/schematic
I3 (in net4 vddd 0) INV_ST W=2u
I8 (IN INN vdd3 0) INV3_ST W=2u
I1 (net4 IN vdd3 0) INV3_ST W=2u
V3 (vddh 0) vsource dc=10 type=dc
V1 (vddd 0) vsource dc=1.8 type=dc
V0 (vdd3 0) vsource dc=3.3 type=dc
V2 (in 0) vsource type=pulse val0=0 val1=1.8 period=100u delay=50u rise=1p fall=1p width=50u
M3 (OUTN OUT vddh vddh 0) pmma_bjt w=Wp l=2.9u m=(1)*(1)
M2 (OUT OUTN vddh vddh 0) pmma_bjt w=Wp l=2.9u m=(1)*(1)
M9 (OUT INN 0 0) nmma_bjt w=Wn l=2.9u m=(1)*(1)
M8 (OUTN IN 0 0) nmma_bjt w=Wn l=2.9u m=(1)*(1)
simulatorOptions options reltol=100e-6 temp=27 homotopy=all limit=delta compatible=spice2
tran tran stop=500u errpreset=conservative
