// Design: Stimulator_TestBench/TB_inv10
simulator lang=spectre
global 0
include "/pkg/xfab/XKIT/xh018/cadence/v8_0/spectre/v8_0_1/lpmos/config.scs" section=default
include "/pkg/xfab/XKIT/xh018/cadence/v8_0/spectre/v8_0_1/lpmos/param.scs" section=3s
include "/pkg/xfab/XKIT/xh018/cadence/v8_0/spectre/v8_0_1/lpmos/bip.scs" section=tm
include "/pkg/xfab/XKIT/xh018/cadence/v8_0/spectre/v8_0_1/lpmos/cap.scs" section=tm
include "/pkg/xfab/XKIT/xh018/cadence/v8_0/spectre/v8_0_1/lpmos/dio.scs" section=tm
include "/pkg/xfab/XKIT/xh018/cadence/v8_0/spectre/v8_0_1/lpmos/mos.scs" section=tm
include "/pkg/xfab/XKIT/xh018/cadence/v8_0/spectre/v8_0_1/lpmos/photo.scs" section=tm
include "/pkg/xfab/XKIT/xh018/cadence/v8_0/spectre/v8_0_1/lpmos/res.scs" section=tm

// Stimulator_IMP/INV10_ST/schematic
subckt INV10_ST in out vdd10 vss
parameters W=5u
    M0 (out in vss vss) nmma_bjt w=W l=2.9u m=(1)*(1)
    M1 (out in vdd10 vdd10 vss) pmma_bjt w=2*W l=2.9u m=(1)*(1)
ends INV10_ST

// Stimulator_TestBench/TB_inv10/schematic
I0 (in out net3 0) INV10_ST W=5u
V0 (in 0) vsource type=pulse val0=0 val1=10 period=100u delay=50u rise=1p fall=1p width=50u
C0 (out 0) capacitor c=1p
V1 (net3 0) vsource dc=10 type=dc
simulatorOptions options reltol=100e-6 temp=27 homotopy=all limit=delta compatible=spice2
tran tran stop=500u errpreset=conservative
