// AMS netlist generated by the AMS Unified netlister
// IC subversion:  IC6.1.8-64b.500.7
// Xcelium version: 18.03-s018
// Copyright(C) 2005-2009, Cadence Design Systems, Inc
// User: ykhuang Pid: 6674
// Design library name: EMG_202009
// Design cell name: TB_VGA
// Design view name: config
// Solver: Spectre

`include "disciplines.vams"
`include "userDisciplines.vams"
// HDL file - EMG_202009, Counter_Nbit, functional.
// HDL file - EMG_202009, PGA_3Bit, verilogams.
// HDL file - EMG_202009, VGA, verilogams.
// Library - EMG_202009, Cell - TB_VGA, View - schematic
// LAST TIME SAVED: Sep 30 17:09:09 2020
// NETLIST TIME: Sep 30 17:10:04 2020

`worklib EMG_202009
`view schematic

`timescale 1ns / 1ps
(* cds_ams_schematic *)

module TB_VGA ( );
wire [2:0] Gain_Sel;
wire Vin;
wire Vdda;
wire CLK;
wire Vout;
wire Ibias;
wire Vout2;
VGA I0 (.Vout( Vout ), .Gain_Sel( CLK ), .Vdda( Vdda ), .Vin( Vin ), .Vssa(cds_globals.\gnd! ));
PGA_3Bit I3 (.Vout( Vout2 ), .Gain_Sel( Gain_Sel ), .Ibias( Ibias ), .Vdda( Vdda ), .Vin( Vin ), .Vssa(cds_globals.\gnd! ));
Counter_Nbit I5 (.out( Gain_Sel ), .Clk( CLK ), .Reset(cds_globals.\gnd! ));
vsource #(.type("sine"), .ampl(0.005), .freq(100)) V0 (Vin, cds_globals.\gnd! );
vsource #(.dc(1.8), .type("dc")) V1 (Vdda, cds_globals.\gnd! );
vsource #(.type("pulse"), .val0(0), .val1(1.8), .period(0.06), .delay(0.06), .rise(1e-09), .fall(1e-09), .width(0.03)) V2 (CLK, cds_globals.\gnd! );
isource #(.dc(1e-05), .type("dc")) I6 (Ibias, Vdda);

endmodule
`noworklib
`noview
