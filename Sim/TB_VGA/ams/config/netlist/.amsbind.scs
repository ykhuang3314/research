// -----------------------------------------------------------------------------
// (c) Copyright 2010 Cadence Design Systems, Inc. All rights reserved worldwide.
// -----------------------------------------------------------------------------

// Binding AMSD Control Block for config EMG_202009.TB_VGA:config
// Created On: Sep 30 17:10:06 2020
// NOTE      : DO NOT change this system generated file.

amsd {
	config designtop="EMG_202009.TB_VGA:schematic"

	config cell="PGA_3Bit" lib="EMG_202009" view="verilogams"
	config cell="VGA" lib="EMG_202009" view="verilogams"
	config cell="isource" view="analogtext"
	config cell="vsource" view="analogtext"
	config cell="Counter_Nbit" lib="EMG_202009" view="functional"

 }
