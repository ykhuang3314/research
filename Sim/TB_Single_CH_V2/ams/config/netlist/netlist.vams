// AMS netlist generated by the AMS Unified netlister
// IC subversion:  IC6.1.8-64b.500.7
// Xcelium version: 18.03-s018
// Copyright(C) 2005-2009, Cadence Design Systems, Inc
// User: ykhuang Pid: 9799
// Design library name: Stimulator_TestBench
// Design cell name: TB_Single_CH_V2
// Design view name: config
// Solver: Spectre

`include "disciplines.vams"
`include "userDisciplines.vams"
// HDL file - Stimulator_Model, CH_SEL_MUX_V2, verilogams.
// HDL file - Stimulator_Model, Current_Source, verilogams.
// HDL file - Stimulator_Model, Digital_Stimulus_ST_V2, functional.
// HDL file - Stimulator_Model, Current_Mirror, verilogams.
// HDL file - Stimulator_Model, H_Bridge, verilogams.
// Library - Stimulator_TestBench, Cell - TB_Single_CH_V2, View - schematic
// LAST TIME SAVED: Feb 22 17:42:33 2021
// NETLIST TIME: Feb 22 17:47:03 2021

`worklib Stimulator_TestBench
`view schematic

`timescale 1ns / 1ps
(* cds_ams_schematic *)

module TB_Single_CH_V2 ( );
wire [1:0] CH_SEL_U_ST;
wire [4:0] MAG_ST;
wire [1:0] CH_SEL_D_ST;
wire DIS_ST;
wire CAT_ST;
wire ANO_ST;
wire net11;
wire net5;
wire vssa;
wire vdda;
wire vddh;
wire Ist;
wire vddd;
wire vssd;
wire EN_ST;
wire Iout_dac;
wire net8;
wire enable;
wire net7;
wire net9;
wire net23;
wire net19;
wire net016;
wire net014;
wire net21;
wire net17;
wire net22;
wire net24;
H_Bridge I0 (.Vssd( vssd ), .Vddd( vddd ), .Ist( Ist ), .VddH( vddh ), .Vdda( vdda ), .Vssa( vssa ), .Iano( net5 ), .Icat( net11 ), .ANO( ANO_ST ), .CAT( CAT_ST ), .DIS( DIS_ST ));
Current_Mirror I1 (.ANO( ANO_ST ), .CAT( CAT_ST ), .Iref( Iout_dac ), .EN( EN_ST ), .Iout( Ist ), .Vdda( vdda ), .Vssa( vssa ));
Digital_Stimulus_ST_V2 I2 (.CH_SEL_D_ST( CH_SEL_D_ST ), .CH_SEL_U_ST( CH_SEL_U_ST ), .ANO_ST( ANO_ST ), .CAT_ST( CAT_ST ), .DIS_ST( DIS_ST ), .EN_ST( EN_ST ), .MAG_ST( MAG_ST ), .ch_sweeping( net7 ), .enable( enable ), .ramping( net8 ));
Current_Source I3 (.EN( EN_ST ), .Vssd( vssd ), .Vddd( vddd ), .Ibias( net9 ), .Vdda( vdda ), .Vssa( vssa ), .Ioutn( Iout_dac ), .Ioutp( vdda ), .Mag( MAG_ST ));
CH_SEL_MUX_V2 I8 (.IN( net11 ), .OUT0( net014 ), .OUT1( net016 ), .OUT2( net19 ), .OUT3( net23 ), .Vdda( vdda ), .Vddd( vddd ), .Vssa( vssa ), .Vssd( vssd ), .CH_SEL( CH_SEL_D_ST ));
CH_SEL_MUX_V2 I6 (.IN( net5 ), .OUT0( net24 ), .OUT1( net22 ), .OUT2( net17 ), .OUT3( net21 ), .Vdda( vdda ), .Vddd( vddd ), .Vssa( vssa ), .Vssd( vssd ), .CH_SEL( CH_SEL_U_ST ));
isource #(.dc(1e-05), .type("dc")) I4 (vdda, net9);
vsource #(.dc(0), .type("dc")) V7 (vssd, cds_globals.\gnd! );
vsource #(.dc(0), .type("dc")) V8 (vssa, cds_globals.\gnd! );
vsource #(.dc(40), .type("dc")) V4 (vddh, cds_globals.\gnd! );
vsource #(.dc(1.8), .type("dc")) V3 (vdda, cds_globals.\gnd! );
vsource #(.dc(1.8), .type("dc")) V6 (vddd, cds_globals.\gnd! );
vsource #(.dc(1.8), .type("dc")) V2 (net7, cds_globals.\gnd! );
vsource #(.dc(0), .type("dc")) V1 (net8, cds_globals.\gnd! );
vsource #(.type("pwl"), .wave({"0", "0", "1e-05", "1.8"})) V0 (enable, cds_globals.\gnd! );
resistor #(.r(1000)) R20 (net06, net08);
resistor #(.r(1000)) R19 (net05, net06);
resistor #(.r(1000)) R18 (net17, net06);
resistor #(.r(1000)) R17 (net06, net19);
resistor #(.r(1000)) R16 (net05, net23);
resistor #(.r(1000)) R15 (net21, net05);
resistor #(.r(1000)) R14 (net08, net010);
resistor #(.r(1000)) R13 (net24, net010);
resistor #(.r(1000)) R12 (net010, net014);
resistor #(.r(1000)) R11 (net08, net016);
resistor #(.r(1000)) R10 (net22, net08);

endmodule
`noworklib
`noview
