// AMS netlist generated by the AMS Unified netlister
// IC subversion:  IC6.1.8-64b.500.7
// Xcelium version: 18.03-s018
// Copyright(C) 2005-2009, Cadence Design Systems, Inc
// User: ykhuang Pid: 8748
// Design library name: EMG_202009
// Design cell name: TB_BPF
// Design view name: config
// Solver: Spectre

`include "disciplines.vams"
`include "userDisciplines.vams"
// HDL file - EMG_202009, BPF_V2, verilogams.
// HDL file - EMG_202009, BPF, verilogams.
// Library - EMG_202009, Cell - TB_BPF, View - schematic
// LAST TIME SAVED: Oct 13 23:05:42 2020
// NETLIST TIME: Oct 13 23:48:28 2020

`worklib EMG_202009
`view schematic

`timescale 1ns / 1ps
(* cds_ams_schematic *)

module TB_BPF ( );
wire Vin;
wire Vdda;
wire Vout;
wire Ibias;
wire Vout2;
BPF I0 (.Vout( Vout ), .Vdda( Vdda ), .Vin( Vin ), .Vssa(cds_globals.\gnd! ));
BPF_V2 I3 (.Vout( Vout2 ), .Ibias( Ibias ), .Vdda( Vdda ), .Vin( Vin ), .Vssa(cds_globals.\gnd! ));
vsource #(.mag(1), .type("sine")) V0 (Vin, cds_globals.\gnd! );
vsource #(.dc(1.8), .type("dc")) V1 (Vdda, cds_globals.\gnd! );

endmodule
`noworklib
`noview
