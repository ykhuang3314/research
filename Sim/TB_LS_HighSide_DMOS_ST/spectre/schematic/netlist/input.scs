// Design: Stimulator_TestBench/TB_LS_HighSide_DMOS_ST
simulator lang=spectre
global 0
include "/pkg/xfab/XKIT/xh018/cadence/v8_0/spectre/v8_0_1/lpmos/config.scs" section=default
include "/pkg/xfab/XKIT/xh018/cadence/v8_0/spectre/v8_0_1/lpmos/param.scs" section=3s
include "/pkg/xfab/XKIT/xh018/cadence/v8_0/spectre/v8_0_1/lpmos/bip.scs" section=tm
include "/pkg/xfab/XKIT/xh018/cadence/v8_0/spectre/v8_0_1/lpmos/cap.scs" section=tm
include "/pkg/xfab/XKIT/xh018/cadence/v8_0/spectre/v8_0_1/lpmos/dio.scs" section=tm
include "/pkg/xfab/XKIT/xh018/cadence/v8_0/spectre/v8_0_1/lpmos/mos.scs" section=tm
include "/pkg/xfab/XKIT/xh018/cadence/v8_0/spectre/v8_0_1/lpmos/photo.scs" section=tm
include "/pkg/xfab/XKIT/xh018/cadence/v8_0/spectre/v8_0_1/lpmos/res.scs" section=tm

// Stimulator_IMP/INV10_ST/schematic
subckt INV10_ST in out vdd10 vss
parameters W=5u
    M0 (out in vss vss) nmma_bjt w=W l=2.9u m=(1)*(1)
    M1 (out in vdd10 vdd10 vss) pmma_bjt w=2*W l=2.9u m=(1)*(1)
ends INV10_ST

// Stimulator_IMP/INV3_ST/schematic
subckt INV3_ST in out vdd3 vss
parameters W=2u
    M1 (out in vdd3 vdd3) pe3 w=2*W l=300n m=(1)*(1)
    M0 (out in vss vss) ne3 w=W l=350.0n m=(1)*(1)
ends INV3_ST

// Stimulator_IMP/LS_LowSide_ST/schematic
subckt LS_LowSide_ST in out outn vdd10 vdd3 vss
    I8 (IN3 IN3_n vdd3 vss) INV3_ST W=2u
    I1 (in IN3 vdd3 vss) INV3_ST W=2u
    I12 (out_LS outn vdd10 vss) INV10_ST W=5u
    I11 (outn_LS out vdd10 vss) INV10_ST W=5u
    M3 (out_LS outn_LS vdd10 vdd10 0) pmma_bjt w=5u l=2.9u m=(1)*(1)
    M2 (outn_LS out_LS vdd10 vdd10 0) pmma_bjt w=5u l=2.9u m=(1)*(1)
    M9 (outn_LS IN3_n vss vss) nmma_bjt w=15.0u l=2.9u m=(1)*(1)
    M8 (out_LS IN3 vss vss) nmma_bjt w=15.0u l=2.9u m=(1)*(1)
ends LS_LowSide_ST

// Stimulator_TestBench/TB_LS_HighSide_DMOS_ST/schematic
V0 (in 0) vsource type=pulse val0=0 val1=1.8 period=100u delay=50u rise=1p fall=1p width=50u
I8 (outn_ls out vddh vssh) INV10_ST W=5u
M5 (outn_ls vssh net20 0) nedia w=10u l=1.25u m=(1)*(1) par1=((1)*(1)) extlay=0 xf_subext=0
M4 (out_ls vssh net19 0) nedia w=10u l=1.25u m=(1)*(1) par1=((1)*(1)) extlay=0 xf_subext=0
M1 (net19 inn_shifted 0 0) nedia w=10u l=1.25u m=(1)*(2) par1=((1)*(2)) extlay=0 xf_subext=0
M0 (net20 in_shifted 0 0) nedia w=10u l=1.25u m=(1)*(2) par1=((1)*(2)) extlay=0 xf_subext=0
M3 (outn_ls out_ls vddh vddh 0) pmma_bjt w=5u l=2.9u m=(1)*(1)
M2 (out_ls outn_ls vddh vddh 0) pmma_bjt w=5u l=2.9u m=(1)*(1)
V5 (vdd10 0) vsource dc=10 type=dc
V4 (vssh 0) vsource dc=30 type=dc
V3 (vddh 0) vsource dc=40 type=dc
V1 (vdd3 0) vsource dc=3.3 type=dc
M7 (outn_ls vssh vssh vssh) nmma_bjt w=5u l=2.9u m=(1)*(1)
M6 (out_ls vssh vssh vssh) nmma_bjt w=5u l=2.9u m=(1)*(1)
I12 (in in_shifted inn_shifted vdd10 vdd3 0) LS_LowSide_ST
simulatorOptions options reltol=100e-6 temp=27 homotopy=all limit=delta compatible=spice2
dcOp dc
