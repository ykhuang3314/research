// Design: Stimulator_TestBench/TB_CurrentMirror_DC_imp
simulator lang=spectre
global 0 vdde! vdd3!
include "/pkg/xfab/XKIT/xh018/cadence/v8_0/spectre/v8_0_1/lpmos/config.scs" section=default
include "/pkg/xfab/XKIT/xh018/cadence/v8_0/spectre/v8_0_1/lpmos/param.scs" section=3s
include "/pkg/xfab/XKIT/xh018/cadence/v8_0/spectre/v8_0_1/lpmos/bip.scs" section=tm
include "/pkg/xfab/XKIT/xh018/cadence/v8_0/spectre/v8_0_1/lpmos/cap.scs" section=tm
include "/pkg/xfab/XKIT/xh018/cadence/v8_0/spectre/v8_0_1/lpmos/dio.scs" section=tm
include "/pkg/xfab/XKIT/xh018/cadence/v8_0/spectre/v8_0_1/lpmos/mos.scs" section=tm
include "/pkg/xfab/XKIT/xh018/cadence/v8_0/spectre/v8_0_1/lpmos/photo.scs" section=tm
include "/pkg/xfab/XKIT/xh018/cadence/v8_0/spectre/v8_0_1/lpmos/res.scs" section=tm

// GATES_3V/invrv3/schematic
subckt invrv3 in out inh_ground_gnd inh_power_vdd3
parameters GT_PDW GT_PDL=350.00n sx=4.8e-07 lc=2.7e-07 GT_PUW GT_PUL=300.00n
    MN1 (out in inh_ground_gnd inh_ground_gnd) ne3 w=GT_PDW l=GT_PDL m=(1)*(1)
    MP1 (out in inh_power_vdd3 inh_power_vdd3) pe3 w=GT_PUW l=GT_PUL m=(1)*(1)
ends invrv3

// D_CELLS_3V/IN_3VX2/cmos_sch
subckt IN_3VX2 A Q inh_ground_gnd inh_power_vdd3
    invr_1 (A Q inh_ground_gnd inh_power_vdd3) invrv3 GT_PDW=960.00n GT_PDL=350.00n sx=4.8e-07 lc=2.7e-07 GT_PUW=2.94u GT_PUL=300.00n
ends IN_3VX2

// D_CELLS_M3V/LSHVT18U3VX1/cmos_sch
subckt LSHVT18U3VX1 A Q inh_ground_gnd inh_power_vdd3 inh_power_vdde
    M6 (Q net20 inh_power_vdd3 inh_power_vdd3) pe3 w=1.46u l=300n m=(1)*(1)
    M8 (net4 A inh_power_vdde inh_power_vdd3) pe3 w=1.48u l=300n m=(1)*(1)
    M9 (net20 A net024 inh_power_vdd3) pe3 w=420.0n l=300n m=(1)*(1)
    M0 (net10 net4 net023 inh_power_vdd3) pe3 w=420.0n l=300n m=(1)*(1)
    M2 (net023 net20 inh_power_vdd3 inh_power_vdd3) pe3 w=420.0n l=300n m=(1)*(1)
    M4 (net024 net10 inh_power_vdd3 inh_power_vdd3) pe3 w=420.0n l=300n m=(1)*(1)
    M3 (net20 A inh_ground_gnd inh_ground_gnd) ne3 w=1.31u l=350.0n m=(1)*(1)
    M5 (Q net20 inh_ground_gnd inh_ground_gnd) ne3 w=890.0n l=350.0n m=(1)*(1)
    M7 (net4 A inh_ground_gnd inh_ground_gnd) ne3 w=420.0n l=350.0n m=(1)*(1)
    M1 (net10 net4 inh_ground_gnd inh_ground_gnd) ne3 w=1.31u l=350.0n m=(1)*(1)
ends LSHVT18U3VX1

// Stimulator_TestBench/TB_CurrentMirror_DC_imp/schematic
I31 (net57 D0_3v 0 vdd3!) IN_3VX2
I3 (net72 D1_3v 0 vdd3!) IN_3VX2
I5 (net71 D2_3v 0 vdd3!) IN_3VX2
I7 (net70 D3_3v 0 vdd3!) IN_3VX2
I9 (net75 D4_3v 0 vdd3!) IN_3VX2
I18 (en_3v enb_3v 0 vdd3!) IN_3VX2
M25 (net081 net026 0 0) ne3 w=20u l=1u m=(1)*(1)
M24 (VBp2 net027 net081 0) ne3 w=20u l=1u m=(1)*(1)
M20 (net026 net026 0 0) ne3 w=20u l=1u m=(1)*(1)
M19 (net027 net027 net026 0) ne3 w=20u l=1u m=(1)*(1)
M43 (vdd3! net2 net37 0) ne3 w=2u l=1u m=(1)*(1)
M37 (net08 net37 net8 0) ne3 w=10u l=350.0n m=(1)*(1)
M28 (net37 net8 0 0) ne3 w=10u l=350.0n m=(1)*(1)
M53 (net2 net2 0 0) ne3 w=2u l=5u m=(1)*(1)
M26 (net14 net14 0 0) ne3 w=40u l=2u m=(1)*(1)
M13 (net078 net14 0 0) ne3 w=40u l=2u m=(1)*(10)
M40 (net14 enb_3v 0 0) ne3 w=2u l=350.0n m=(1)*(1)
M10 (net078 net035 0 0) nedia_bjt w=10u l=1.25u m=(1)*(1) par1=((1)*(1)) extlay=0 xf_subext=0
M9 (net035 vdd3! 0 0) nedia_bjt w=10u l=1.25u m=(1)*(1) par1=((1)*(1)) extlay=0 xf_subext=0
M21 (net33 net33 net32 0) nedia_bjt w=15.0u l=1.25u m=(1)*(1) par1=((1)*(1)) extlay=0 xf_subext=0
M16 (Bias2 vdd3! net078 0) nedia_bjt w=50u l=1.25u m=(1)*(5) par1=((1)*(5)) extlay=0 xf_subext=0
M8 (net29 net29 VB 0) nedia_bjt w=60u l=1.25u m=(10)*(1) par1=((10)*(1)) extlay=0 xf_subext=0
M5 (net32 VB net74 0) nedia_bjt w=60u l=1.25u m=(1)*(1) par1=((1)*(1)) extlay=0 xf_subext=0
M0 (net58 VB net73 0) nedia_bjt w=60u l=1.25u m=(10)*(1) par1=((10)*(1)) extlay=0 xf_subext=0
M7 (VB net29 net28 0) nedia_bjt w=20u l=1.25u m=(1)*(1) par1=((1)*(1)) extlay=0 xf_subext=0
M6 (net28 net28 0 0) nedia_bjt w=60u l=1.25u m=(10)*(1) par1=((10)*(1)) extlay=0 xf_subext=0
M4 (net74 net32 0 0) nedia_bjt w=60u l=1.25u m=(1)*(1) par1=((1)*(1)) extlay=0 xf_subext=0
M3 (net73 net32 0 0) nedia_bjt w=60u l=1.25u m=(10)*(1) par1=((10)*(1)) extlay=0 xf_subext=0
I17 (EN_ST en_3v 0 vdd3! vdde!) LSHVT18U3VX1
I0 (MAG_ST\<0\> net57 0 vdd3! vdde!) LSHVT18U3VX1
I30 (MAG_ST\<1\> net72 0 vdd3! vdde!) LSHVT18U3VX1
I4 (MAG_ST\<2\> net71 0 vdd3! vdde!) LSHVT18U3VX1
I6 (MAG_ST\<3\> net70 0 vdd3! vdde!) LSHVT18U3VX1
I29 (MAG_ST\<4\> net75 0 vdd3! vdde!) LSHVT18U3VX1
M2 (net012 net012 vdd3! vdd3!) pe3 w=10u l=1u m=(1)*(1)
M1 (VBp2 VBp2 net012 vdd3!) pe3 w=10u l=1u m=(1)*(1)
M50 (net69 net021 vdd3! vdd3!) pe3 w=10u l=1u m=(1)*(1)
M41 (net60 net012 vdd3! vdd3!) pe3 w=10u l=1u m=(1)*(16)
M38 (net62 net012 vdd3! vdd3!) pe3 w=10u l=1u m=(1)*(8)
M35 (net64 net012 vdd3! vdd3!) pe3 w=10u l=1u m=(1)*(4)
M32 (net66 net012 vdd3! vdd3!) pe3 w=10u l=1u m=(1)*(2)
M22 (net68 net012 vdd3! vdd3!) pe3 w=10u l=1u m=(1)*(1)
M48 (net021 net021 vdd3! vdd3!) pe3 w=10u l=1u m=(1)*(1)
M54 (net2 net2 vdd3! vdd3!) pe3 w=6u l=5u m=(1)*(1)
M51 (net37 net08 net69 vdd3!) pe3 w=10u l=1u m=(1)*(1)
M42 (net59 VBp2 net60 vdd3!) pe3 w=10u l=1u m=(1)*(16)
M39 (net61 VBp2 net62 vdd3!) pe3 w=10u l=1u m=(1)*(8)
M36 (net63 VBp2 net64 vdd3!) pe3 w=10u l=1u m=(1)*(4)
M33 (net65 VBp2 net66 vdd3!) pe3 w=10u l=1u m=(1)*(2)
M29 (net67 VBp2 net68 vdd3!) pe3 w=10u l=1u m=(1)*(1)
M49 (net08 net08 net021 vdd3!) pe3 w=10u l=1u m=(1)*(1)
M44 (net14 D1_3v net65 vdd3!) pe3 w=10u l=300n m=(1)*(1)
M45 (net14 D2_3v net63 vdd3!) pe3 w=10u l=300n m=(1)*(1)
M46 (net14 D3_3v net61 vdd3!) pe3 w=10u l=300n m=(1)*(1)
M47 (net14 D4_3v net59 vdd3!) pe3 w=10u l=300n m=(1)*(1)
M31 (net14 D0_3v net67 vdd3!) pe3 w=10u l=300n m=(1)*(1)
M52 (net078 en_3v vdd3! vdd3!) pe3 w=2u l=300n m=(1)*(1)
R3 (net080 net027) rpp1k1 l=20.095u w=2u m=1 par1=(1)
R1 (net8 0) rpp1k1 l=150.295u w=2u m=1 par1=(1)
R0 (vddh net58) resistor r=1.1k
M11 (net55 net028 vddh 0) ped_bjt w=30u l=940.0n m=(1)*(1) par1=((1)*(1)) extlay=0 xf_subext=0
M14 (net29 Bias2 net56 0) ped_bjt w=30u l=940.0n m=(1)*(1) par1=((1)*(1)) extlay=0 xf_subext=0
M18 (Bias2 Bias2 net028 0) ped_bjt w=30u l=940.0n m=(1)*(1) par1=((1)*(1)) extlay=0 xf_subext=0
M12 (net33 Bias2 net55 0) ped_bjt w=30u l=940.0n m=(1)*(1) par1=((1)*(1)) extlay=0 xf_subext=0
M15 (net56 net028 vddh 0) ped_bjt w=30u l=940.0n m=(1)*(1) par1=((1)*(1)) extlay=0 xf_subext=0
M17 (net028 net028 vddh 0) ped_bjt w=30u l=940.0n m=(1)*(1) par1=((1)*(1)) extlay=0 xf_subext=0
V9 (EN_ST 0) vsource dc=1.8 type=dc
V8 (MAG_ST\<4\> 0) vsource dc=0 type=dc
V7 (MAG_ST\<3\> 0) vsource dc=0 type=dc
V6 (MAG_ST\<2\> 0) vsource dc=0 type=dc
V5 (MAG_ST\<1\> 0) vsource dc=0 type=dc
V2 (MAG_ST\<0\> 0) vsource dc=1.8 type=dc
V4 (vdde! 0) vsource dc=1.8 type=dc
V3 (vdd3! 0) vsource dc=3.3 type=dc
V0 (vddh 0) vsource dc=40 type=dc
V12 (net046 0) vsource type=pwl wave=[ 0 0 100u 0 101u 3.3 ]
V11 (net048 0) vsource type=pwl wave=[ 0 0 50u 0 51u 40 ]
C5 (vddh net035) csft5a area=6.3936e-11 perimeter=33.72u m=15 par1=(15)
C1 (net035 0) csft5a area=6.3936e-11 perimeter=33.72u m=45 par1=(45)
I35 (vdd3! net080) isource dc=10u type=dc
simulatorOptions options reltol=100e-6 temp=27 homotopy=all limit=delta compatible=spice2
dcOp dc
