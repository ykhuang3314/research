// -----------------------------------------------------------------------------
// (c) Copyright 2010 Cadence Design Systems, Inc. All rights reserved worldwide.
// -----------------------------------------------------------------------------

// Binding AMSD Control Block for config IL2239_SAR_ADC.SAR4_sim:config
// Created On: Apr 14 21:39:12 2021
// NOTE      : DO NOT change this system generated file.

amsd {
	config designtop="IL2239_SAR_ADC.SAR4_sim:schematic"

	config cell="digital_stimuli_SAR4" lib="IL2239_SAR_ADC" view="verilogams"
	config cell="SAR4" lib="IL2239_SAR_ADC" view="verilogams"
	config cell="vsource" view="analogtext"

 }
