// AMS netlist generated by the AMS Unified netlister
// IC subversion:  IC6.1.8-64b.500.7
// Xcelium version: 18.03-s018
// Copyright(C) 2005-2009, Cadence Design Systems, Inc
// User: ykhuang Pid: 13526
// Design library name: IL2239_SAR_ADC
// Design cell name: SAR4_sim
// Design view name: config
// Solver: Spectre

`include "disciplines.vams"
`include "userDisciplines.vams"
// HDL file - IL2239_SAR_ADC, digital_stimuli_SAR4, verilogams.
// HDL file - IL2239_SAR_ADC, SAR4, verilogams.
// Library - IL2239_SAR_ADC, Cell - SAR4_sim, View - schematic
// LAST TIME SAVED: Apr 13 10:48:14 2021
// NETLIST TIME: Apr 14 21:39:10 2021

`worklib IL2239_SAR_ADC
`view schematic

`timescale 1ns / 1ps
(* cds_ams_schematic *)

module SAR4_sim ( );
wire start;
wire comp;
wire clock;
wire out3;
wire out2;
wire out1;
wire out0;
wire eoc;
wire SW_ref;
wire SW_inp;
wire DAC_out3;
wire DAC_out2;
wire DAC_out1;
wire DAC_out0;
SAR4 I0 (.DAC_out0( DAC_out0 ), .DAC_out1( DAC_out1 ), .DAC_out2( DAC_out2 ), .DAC_out3( DAC_out3 ), .SW_inp( SW_inp ), .SW_ref( SW_ref ), .eoc( eoc ), .out0( out0 ), .out1( out1 ), .out2( out2 ), .out3( out3 ), .clock( clock ), .comp( comp ), .reset(cds_globals.\gnd! ), .start( start ));
digital_stimuli_SAR4 I1 (.comp( comp ), .start( start ));
vsource #(.type("pulse"), .val0(0), .val1(1.8), .period(5e-08), .rise(0.01*50e-9), .fall(0.01*50e-9), .width(2.5e-08)) V0 (clock, cds_globals.\gnd! );

endmodule
`noworklib
`noview
