// Design: Stimulator_TestBench/TB_TCA
simulator lang=spectre
global 0
parameters vdac=1.5
include "/pkg/xfab/XKIT/xh018/cadence/v8_0/spectre/v8_0_1/lpmos/config.scs" section=default
include "/pkg/xfab/XKIT/xh018/cadence/v8_0/spectre/v8_0_1/lpmos/param.scs" section=3s
include "/pkg/xfab/XKIT/xh018/cadence/v8_0/spectre/v8_0_1/lpmos/bip.scs" section=tm
include "/pkg/xfab/XKIT/xh018/cadence/v8_0/spectre/v8_0_1/lpmos/cap.scs" section=tm
include "/pkg/xfab/XKIT/xh018/cadence/v8_0/spectre/v8_0_1/lpmos/dio.scs" section=tm
include "/pkg/xfab/XKIT/xh018/cadence/v8_0/spectre/v8_0_1/lpmos/mos.scs" section=tm
include "/pkg/xfab/XKIT/xh018/cadence/v8_0/spectre/v8_0_1/lpmos/photo.scs" section=tm
include "/pkg/xfab/XKIT/xh018/cadence/v8_0/spectre/v8_0_1/lpmos/res.scs" section=tm

// Stimulator_TestBench/TB_TCA/schematic
R1 (net06 net07) resistor r=1K
R0 (net3 0) resistor r=50
V3 (vddh 0) vsource dc=40 type=dc
V2 (vddh net09) vsource dc=10 type=dc
V1 (net05 0) vsource dc=10 type=dc
V0 (net2 0) vsource dc=vdac type=dc
E0 (net4 0 net2 net3) vcvs gain=500
M0 (net013 net4 net3 0) nmma_bjt w=35.0u l=2.9u m=(1)*(10)
M1 (net06 net05 net013 0) nedia_bjt w=20u l=1.25u m=(1)*(20) par1=((1)*(20)) extlay=0 xf_subext=0
M2 (net07 net09 vddh 0) ped_bjt w=40u l=940.0n m=(1)*(20) par1=((1)*(20)) extlay=0 xf_subext=0
simulatorOptions options reltol=100e-6 temp=27 homotopy=all limit=delta compatible=spice2
dcOp dc
