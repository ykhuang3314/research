// AMS netlist generated by the AMS Unified netlister
// IC subversion:  IC6.1.8-64b.500.7
// Xcelium version: 18.03-s018
// Copyright(C) 2005-2009, Cadence Design Systems, Inc
// User: ykhuang Pid: 1354
// Design library name: Stimulator_TestBench
// Design cell name: TB_Digital_Stimuli
// Design view name: config
// Solver: Spectre

`include "disciplines.vams"
`include "userDisciplines.vams"
// Library - Stimulator_TestBench, Cell - TB_Digital_Stimuli, View -
//schematic
// LAST TIME SAVED: Mar 25 14:59:47 2021
// NETLIST TIME: Mar 25 14:59:53 2021
`timescale 1ns / 1ps

`worklib Stimulator_TestBench
`view schematic

(* cds_ams_schematic *)

module TB_Digital_Stimuli ();

// Buses in the design

wire  [4:0]  MAG_ST;

Digital_Stimulus_ST #( .Ramping(1'b1) ) I0 ( .ANO_ST(ANO_ST),
    .CAT_ST(CAT_ST), .DIS_ST(DIS_ST), .EN_ST(EN_ST), .MAG_ST(MAG_ST));

endmodule
`noworklib
`noview

 // END AMS-UNL Netlist
