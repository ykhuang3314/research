// AMS netlist generated by the AMS Unified netlister
// IC subversion:  IC6.1.8-64b.500.7
// Xcelium version: 18.03-s018
// Copyright(C) 2005-2009, Cadence Design Systems, Inc
// User: ykhuang Pid: 4981
// Design library name: Stimulator_TestBench
// Design cell name: TB_HBridge_V2
// Design view name: config
// Solver: Spectre

`include "disciplines.vams"
`include "userDisciplines.vams"
// HDL file - Stimulator_Model, Current_Source, verilogams.
// HDL file - Stimulator_Model, Digital_Stimulus_ST_V2, functional.
// HDL file - D_CELLS_M3V, LSHVT18U3VX1, verilogams.
// HDL file - Stimulator_Model, Current_Mirror, verilogams.
// Library - Stimulator_IMP, Cell - LS_HighSide_V3_ST, View - schematic
// LAST TIME SAVED: Mar 15 15:50:43 2021
// NETLIST TIME: Mar 15 15:50:54 2021

`worklib Stimulator_IMP
`view schematic

`timescale 1ns / 1ps
(* cds_ams_schematic *)

module LS_HighSide_V3_ST (out, .\gnd! (cdsNet2), .\vdd3! (cdsNet1), .\vdde! (cdsNet0), vddh, in);
output  out;
input  in;
inout  cdsNet2, cdsNet1, cdsNet0, vddh;
wire inn3v;
cds_alias #(1) cds_alias_inst1 ( cdsNet2 , cds_globals.\gnd! );
cds_alias #(1) cds_alias_inst2 ( cdsNet1 , cds_globals.\vdd3! );
cds_alias #(1) cds_alias_inst3 ( cdsNet0 , cds_globals.\vdde! );
LSHVT18U3VX1 I10 (.A( in ), .Q( inn3v ));
resistor #(.r(100000)) R9 (vddh, out);
resistor #(.r(300000)) R8 (out, net10);
nedia_bjt #(.w(1e-05), .l(1.25e-06), .m((1)*(5)), .par1((1)*(5)), .extlay(0), .xf_subext(0))
(* integer passed_mfactor = "m"; *)
 M13 (net10, inn3v, cds_globals.\gnd! , cds_globals.\gnd! );

endmodule
// Library - Stimulator_IMP, Cell - LS_LowSide_V2_ST, View - schematic
// LAST TIME SAVED: Mar 15 15:20:49 2021
// NETLIST TIME: Mar 15 15:50:54 2021

`worklib Stimulator_IMP
`view schematic

`timescale 1ns / 1ps
(* cds_ams_schematic *)

module LS_LowSide_V2_ST (out, .\gnd! (cdsNet2), .\vdd3! (cdsNet1), .\vdde! (cdsNet0), vddh, in);
output  out;
input  in;
inout  cdsNet2, cdsNet1, cdsNet0, vddh;
wire in_3V;
cds_alias #(1) cds_alias_inst4 ( cdsNet2 , cds_globals.\gnd! );
cds_alias #(1) cds_alias_inst5 ( cdsNet1 , cds_globals.\vdd3! );
cds_alias #(1) cds_alias_inst6 ( cdsNet0 , cds_globals.\vdde! );
LSHVT18U3VX1 I0 (.A( in ), .Q( in_3V ));
nedia_bjt #(.w(1e-05), .l(1.25e-06), .m((1)*(2)), .par1((1)*(2)), .extlay(0), .xf_subext(0))
(* integer passed_mfactor = "m"; *)
 M0 (net12, in_3V, cds_globals.\gnd! , cds_globals.\gnd! );
resistor #(.r(300000)) R1 (net9, net12);
resistor #(.r(100000)) R3 (out, cds_globals.\gnd! );
resistor #(.r(300000)) R2 (net11, out);
resistor #(.r(100000)) R0 (vddh, net9);
ped_bjt #(.w(1e-05), .l(9.4e-07), .m((1)*(2)), .par1((1)*(2)), .extlay(0), .xf_subext(0))
(* integer passed_mfactor = "m"; *)
 M1 (net11, net9, vddh, cds_globals.\gnd! );

endmodule
// Library - Stimulator_TestBench, Cell - TB_HBridge_V2, View - schematic
// LAST TIME SAVED: Mar 15 15:42:14 2021
// NETLIST TIME: Mar 15 15:50:54 2021

`worklib Stimulator_TestBench
`view schematic

`timescale 1ns / 1ps
(* cds_ams_schematic *)

module TB_HBridge_V2 ( );
wire [4:0] MAG_ST;
wire [1:0] CH_SEL_D_ST;
wire [1:0] CH_SEL_U_ST;
wire vdda;
wire Ist;
wire EN_ST;
wire Iout_dac;
wire CAT_ST;
wire ANO_ST;
wire CtrlHS_L;
wire vddh;
wire CtrlHS_R;
wire net10;
wire enable;
wire net9;
wire DIS_ST;
wire CtrlLS_R;
wire CtrlLS_L;
wire net11;
Current_Mirror I10 (.ANO( ANO_ST ), .CAT( CAT_ST ), .Iref( Iout_dac ), .EN( EN_ST ), .Iout( Ist ), .Vdda( vdda ), .Vssa(cds_globals.\gnd! ));
LS_HighSide_V3_ST I0 (.\vdde! (cds_globals.\vdde! ), .\gnd! (cds_globals.\gnd! ), .\vdd3! (cds_globals.\vdd3! ), .vddh( vddh ), .out( CtrlHS_L ), .in( ANO_ST ));
LS_HighSide_V3_ST I1 (.\vdde! (cds_globals.\vdde! ), .\gnd! (cds_globals.\gnd! ), .\vdd3! (cds_globals.\vdd3! ), .vddh( vddh ), .out( CtrlHS_R ), .in( CAT_ST ));
Digital_Stimulus_ST_V2 #(.MAG(5'b11111), .num_of_ch(1)) I7 (.CH_SEL_D_ST( CH_SEL_D_ST ), .ANO_ST( ANO_ST ), .CAT_ST( CAT_ST ), .CH_SEL_U_ST( CH_SEL_U_ST ), .DIS_ST( DIS_ST ), .EN_ST( EN_ST ), .MAG_ST( MAG_ST ), .ch_sweeping( net9 ), .enable( enable ), .ramping( net10 ));
LS_LowSide_V2_ST I4 (.\vdde! (cds_globals.\vdde! ), .\gnd! (cds_globals.\gnd! ), .\vdd3! (cds_globals.\vdd3! ), .vddh( vddh ), .out( CtrlLS_R ), .in( ANO_ST ));
LS_LowSide_V2_ST I2 (.\gnd! (cds_globals.\gnd! ), .\vdd3! (cds_globals.\vdd3! ), .\vdde! (cds_globals.\vdde! ), .vddh( vddh ), .out( CtrlLS_L ), .in( CAT_ST ));
Current_Source I3 (.EN( EN_ST ), .Vssd(cds_globals.\gnd! ), .Vddd(cds_globals.\vdde! ), .Ibias( net11 ), .Vdda( vdda ), .Vssa(cds_globals.\gnd! ), .Ioutn( Iout_dac ), .Ioutp( vdda ), .Mag( MAG_ST ));
vsource #(.dc(1.8), .type("dc")) V1 (net10, cds_globals.\gnd! );
vsource #(.dc(0), .type("dc")) V2 (net9, cds_globals.\gnd! );
vsource #(.dc(1.8), .type("dc")) V6 (cds_globals.\vdde! , cds_globals.\gnd! );
vsource #(.dc(1.8), .type("dc")) V3 (vdda, cds_globals.\gnd! );
vsource #(.dc(40), .type("dc")) V4 (vddh, cds_globals.\gnd! );
vsource #(.dc(3.3), .type("dc")) V11 (cds_globals.\vdd3! , cds_globals.\gnd! );
vsource #(.type("pwl"), .wave({"0", "0", "1e-05", "1.8"})) V0 (enable, cds_globals.\gnd! );
nedia #(.w(2e-05), .l(1.25e-06), .m((1)*(20)), .par1((1)*(20)), .extlay(0), .xf_subext(0))
(* integer passed_mfactor = "m"; *)
 M3 (net7, CtrlLS_R, Ist, cds_globals.\gnd! );
nedia #(.w(2e-05), .l(1.25e-06), .m((1)*(20)), .par1((1)*(20)), .extlay(0), .xf_subext(0))
(* integer passed_mfactor = "m"; *)
 M1 (net5, CtrlLS_L, Ist, cds_globals.\gnd! );
isource #(.dc(1e-05), .type("dc")) I9 (vdda, net11);
resistor #(.r(1000)) R0 (net5, net7);
ped #(.w(4e-05), .l(9.4e-07), .m((1)*(20)), .par1((1)*(20)), .extlay(0), .xf_subext(0))
(* integer passed_mfactor = "m"; *)
 M2 (net7, CtrlHS_R, vddh, cds_globals.\gnd! );
ped #(.w(4e-05), .l(9.4e-07), .m((1)*(20)), .par1((1)*(20)), .extlay(0), .xf_subext(0))
(* integer passed_mfactor = "m"; *)
 M0 (net5, CtrlHS_L, vddh, cds_globals.\gnd! );

endmodule
`noworklib
`noview
