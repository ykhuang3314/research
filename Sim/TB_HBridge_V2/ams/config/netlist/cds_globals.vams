// Verilog-AMS cds_globals module for top-level cell:
//    Stimulator_TestBench/TB_HBridge_V2.
// Generated by ADE.
// Cadence Design Systems, Inc.

// This is an autoGenerated file, any changes done to this file may get lost.

`include "disciplines.vams"
`include "userDisciplines.vams"

module cds_globals;

// Global Signals
   wire \vdd3! ;
   electrical \gnd! ;
   ground \gnd! ;
   wire \vdde! ;

// Design Variables

endmodule
