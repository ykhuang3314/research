// -----------------------------------------------------------------------------
// (c) Copyright 2010 Cadence Design Systems, Inc. All rights reserved worldwide.
// -----------------------------------------------------------------------------

// Binding AMSD Control Block for config Stimulator_TestBench.TB_Digital_Stimulus:config
// Created On: Feb 15 22:30:42 2021
// NOTE      : DO NOT change this system generated file.

amsd {
	config designtop="Stimulator_TestBench.TB_Digital_Stimulus:schematic"

	config cell="Digital_Stimulus_ST_V2" lib="Stimulator_Model" view="functional"
	config cell="vsource" view="analogtext"

 }
