// AMS netlist generated by the AMS Unified netlister
// IC subversion:  IC6.1.8-64b.500.7
// Xcelium version: 18.03-s018
// Copyright(C) 2005-2009, Cadence Design Systems, Inc
// User: ykhuang Pid: 10648
// Design library name: Stimulator_TestBench
// Design cell name: TB_Digital_Stimulus
// Design view name: config
// Solver: Spectre

`include "disciplines.vams"
`include "userDisciplines.vams"
// HDL file - Stimulator_Model, Digital_Stimulus_ST_V2, functional.
// Library - Stimulator_TestBench, Cell - TB_Digital_Stimulus, View - schematic
// LAST TIME SAVED: Feb 15 22:30:29 2021
// NETLIST TIME: Feb 15 22:30:40 2021

`worklib Stimulator_TestBench
`view schematic

`timescale 1ns / 1ps
(* cds_ams_schematic *)

module TB_Digital_Stimulus ( );
wire [4:0] MAG_ST;
wire [1:0] CH_SEL_ST;
wire net3;
wire net02;
wire net1;
wire EN_ST;
wire DIS_ST;
wire CAT_ST;
wire ANO_ST;
Digital_Stimulus_ST_V2 I0 (.ANO_ST( ANO_ST ), .CAT_ST( CAT_ST ), .CH_SEL_ST( CH_SEL_ST ), .DIS_ST( DIS_ST ), .EN_ST( EN_ST ), .MAG_ST( MAG_ST ), .ch_sweeping( net1 ), .enable( net02 ), .ramping( net3 ));
vsource #(.dc(1.8), .type("dc")) V1 (net1, cds_globals.\gnd! );
vsource #(.dc(0), .type("dc")) V0 (net3, cds_globals.\gnd! );
vsource #(.type("pwl"), .wave({"0", "0", "1e-05", "1.8"})) V2 (net02, cds_globals.\gnd! );

endmodule
`noworklib
`noview
