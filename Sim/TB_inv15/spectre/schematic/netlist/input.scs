// Design: Stimulator_TestBench/TB_inv15
simulator lang=spectre
global 0
include "/pkg/xfab/XKIT/xh018/cadence/v8_0/spectre/v8_0_1/lpmos/config.scs" section=default
include "/pkg/xfab/XKIT/xh018/cadence/v8_0/spectre/v8_0_1/lpmos/param.scs" section=3s
include "/pkg/xfab/XKIT/xh018/cadence/v8_0/spectre/v8_0_1/lpmos/bip.scs" section=tm
include "/pkg/xfab/XKIT/xh018/cadence/v8_0/spectre/v8_0_1/lpmos/cap.scs" section=tm
include "/pkg/xfab/XKIT/xh018/cadence/v8_0/spectre/v8_0_1/lpmos/dio.scs" section=tm
include "/pkg/xfab/XKIT/xh018/cadence/v8_0/spectre/v8_0_1/lpmos/mos.scs" section=tm
include "/pkg/xfab/XKIT/xh018/cadence/v8_0/spectre/v8_0_1/lpmos/photo.scs" section=tm
include "/pkg/xfab/XKIT/xh018/cadence/v8_0/spectre/v8_0_1/lpmos/res.scs" section=tm

// Stimulator_IMP/INV15_ST/schematic
subckt INV15_ST in_pd in_pu out vdd10 vdd15 vss
parameters W=5u
    M1 (out vdd10 net12 net12) nmma_bjt w=W l=2.9u m=(1)*(1)
    M0 (net12 in_pd vss vss) nmma_bjt w=W l=2.9u m=(1)*(1)
    M2 (out in_pu vdd15 vdd15 vss) pmma_bjt w=2*W l=2.9u m=(1)*(1)
ends INV15_ST

// Stimulator_TestBench/TB_inv15/schematic
I0 (in_pd in_pu out net3 net2 0) INV15_ST W=5u
V1 (in_pd 0) vsource type=pulse val0=0 val1=10 period=100u delay=50u rise=1p fall=1p width=50u
V0 (in_pu 0) vsource type=pulse val0=0 val1=15 period=100u delay=50u rise=1p fall=1p width=50u
V3 (net2 0) vsource dc=15 type=dc
V2 (net3 0) vsource dc=10 type=dc
C0 (out 0) capacitor c=1p
simulatorOptions options reltol=100e-6 temp=27 homotopy=all limit=delta compatible=spice2
tran tran stop=500u errpreset=conservative
