// AMS netlist generated by the AMS Unified netlister
// IC subversion:  IC6.1.8-64b.500.7
// Xcelium version: 18.03-s018
// Copyright(C) 2005-2009, Cadence Design Systems, Inc
// User: ykhuang Pid: 6674
// Design library name: EMG_202009
// Design cell name: TB_MultiplexingADC_v2
// Design view name: config
// Solver: Spectre

`include "disciplines.vams"
`include "userDisciplines.vams"
// HDL file - EMG_202009, MUX_16, verilogams.
// HDL file - EMG_202009, DAC, verilogams.
// HDL file - EMG_202009, ADC_V2, verilogams.
// HDL file - EMG_202009, Counter_4bit, functional.
// Library - EMG_202009, Cell - TB_MultiplexingADC_v2, View - schematic
// LAST TIME SAVED: Sep 30 15:17:38 2020
// NETLIST TIME: Sep 30 15:17:53 2020

`worklib EMG_202009
`view schematic

`timescale 1ns / 1ps
(* cds_ams_schematic *)

module TB_MultiplexingADC_v2 ( );
wire [11:0] Dout;
wire [3:0] sel;
wire Start;
wire VrefL;
wire VrefH;
wire Ain;
wire Ibias;
wire Vdda;
wire CLK;
wire EoC;
wire Vout;
wire Vin15;
wire Vin14;
wire Vin13;
wire Vin12;
wire Vin11;
wire Vin10;
wire Vin9;
wire Vin8;
wire Vin7;
wire Vin6;
wire Vin5;
wire Vin4;
wire Vin3;
wire Vin2;
wire Vin1;
wire Vin0;
Counter_4bit I4 (.Q( sel ), .Clk( Start ), .Reset(cds_globals.\gnd! ));
ADC_V2 I1 (.Dout( Dout ), .EoC( EoC ), .Clk( CLK ), .En( Vdda ), .Ibias( Ibias ), .Start( Start ), .Vdda( Vdda ), .Vin( Ain ), .VrefH( VrefH ), .VrefL( VrefL ), .Vssa(cds_globals.\gnd! ));
DAC #(.V_fullscale(1.5), .thresh(0.9)) I2 (.Vout( Vout ), .Clk( CLK ), .Din( Dout ), .Vdda( Vdda ), .Vssa(cds_globals.\gnd! ));
MUX_16 I0 (.Vout( Ain ), .Clk( Start ), .Vdda( Vdda ), .Vin0( Vin0 ), .Vin1( Vin1 ), .Vin2( Vin2 ), .Vin3( Vin3 ), .Vin4( Vin4 ), .Vin5( Vin5 ), .Vin6( Vin6 ), .Vin7( Vin7 ), .Vin8( Vin8 ), .Vin9( Vin9 ), .Vin10( Vin10 ), .Vin11( Vin11 ), .Vin12( Vin12 ), .Vin13( Vin13 ), .Vin14( Vin14 ), .Vin15( Vin15 ), .Vssa(cds_globals.\gnd! ), .sel( sel ));
vsource #(.dc(0), .type("dc")) V20 (VrefL, cds_globals.\gnd! );
vsource #(.dc(1.5), .type("dc")) V19 (VrefH, cds_globals.\gnd! );
vsource #(.dc(1.8), .type("dc")) V18 (Vdda, cds_globals.\gnd! );
vsource #(.dc(15*(1.5/16)), .type("dc")) V16 (Vin15, cds_globals.\gnd! );
vsource #(.dc(14*(1.5/16)), .type("dc")) V17 (Vin14, cds_globals.\gnd! );
vsource #(.dc(12*(1.5/16)), .type("dc")) V13 (Vin12, cds_globals.\gnd! );
vsource #(.dc(13*(1.5/16)), .type("dc")) V12 (Vin13, cds_globals.\gnd! );
vsource #(.dc(10*(1.5/16)), .type("dc")) V11 (Vin10, cds_globals.\gnd! );
vsource #(.dc(11*(1.5/16)), .type("dc")) V10 (Vin11, cds_globals.\gnd! );
vsource #(.dc(8*(1.5/16)), .type("dc")) V9 (Vin8, cds_globals.\gnd! );
vsource #(.dc(9*(1.5/16)), .type("dc")) V8 (Vin9, cds_globals.\gnd! );
vsource #(.dc(6*(1.5/16)), .type("dc")) V7 (Vin6, cds_globals.\gnd! );
vsource #(.dc(7*(1.5/16)), .type("dc")) V6 (Vin7, cds_globals.\gnd! );
vsource #(.dc(4*(1.5/16)), .type("dc")) V5 (Vin4, cds_globals.\gnd! );
vsource #(.dc(5*(1.5/16)), .type("dc")) V4 (Vin5, cds_globals.\gnd! );
vsource #(.dc(2*(1.5/16)), .type("dc")) V3 (Vin2, cds_globals.\gnd! );
vsource #(.dc(3*(1.5/16)), .type("dc")) V2 (Vin3, cds_globals.\gnd! );
vsource #(.dc(0*(1.5/16)), .type("dc")) V1 (Vin0, cds_globals.\gnd! );
vsource #(.dc(1*(1.5/16)), .type("dc")) V0 (Vin1, cds_globals.\gnd! );
vsource #(.type("pulse"), .val0(0), .val1(1.8), .period((1/32e+3)*14), .delay(0), .rise(1e-11), .fall(1e-11), .width((1/32e+3)*7)) V22 (Start, cds_globals.\gnd! );
vsource #(.type("pulse"), .val0(0), .val1(1.8), .period(1/32e+3), .delay(1/64e+3), .rise(1e-12), .fall(1e-12), .width(1/64e+3)) V14 (CLK, cds_globals.\gnd! );
isource #(.dc(1e-05), .type("dc")) I7 (Vdda, Ibias);

endmodule
`noworklib
`noview
