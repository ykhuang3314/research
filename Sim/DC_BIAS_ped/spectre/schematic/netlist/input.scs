// Design: Device_Characteristics/DC_BIAS_ped
simulator lang=spectre
global 0 vdd!
parameters VDS=-20 VGS=0 W=200u
include "/pkg/xfab/XKIT/xh018/cadence/v8_0/spectre/v8_0_1/lpmos/config.scs" section=default
include "/pkg/xfab/XKIT/xh018/cadence/v8_0/spectre/v8_0_1/lpmos/param.scs" section=3s
include "/pkg/xfab/XKIT/xh018/cadence/v8_0/spectre/v8_0_1/lpmos/bip.scs" section=tm
include "/pkg/xfab/XKIT/xh018/cadence/v8_0/spectre/v8_0_1/lpmos/cap.scs" section=tm
include "/pkg/xfab/XKIT/xh018/cadence/v8_0/spectre/v8_0_1/lpmos/dio.scs" section=tm
include "/pkg/xfab/XKIT/xh018/cadence/v8_0/spectre/v8_0_1/lpmos/mos.scs" section=tm
include "/pkg/xfab/XKIT/xh018/cadence/v8_0/spectre/v8_0_1/lpmos/photo.scs" section=tm
include "/pkg/xfab/XKIT/xh018/cadence/v8_0/spectre/v8_0_1/lpmos/res.scs" section=tm

// Device_Characteristics/DC_BIAS_ped/schematic
M0 (net4 net3 vdd! vdd!) ped w=W l=940.0n m=(1)*(1) par1=((1)*(1)) extlay=0 xf_subext=0
V2 (net4 vdd!) vsource dc=VDS type=dc
V1 (net3 vdd!) vsource dc=VGS type=dc
V0 (vdd! 0) vsource dc=40 type=dc
simulatorOptions options reltol=100e-6 temp=27 homotopy=all limit=delta compatible=spice2
dcOp dc
dc dc param=VDS start=0 stop=-40
save M0:1
