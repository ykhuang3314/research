// AMS netlist generated by the AMS Unified netlister
// IC subversion:  IC6.1.8-64b.500.7
// Xcelium version: 18.03-s018
// Copyright(C) 2005-2009, Cadence Design Systems, Inc
// User: ykhuang Pid: 6674
// Design library name: EMG_202009
// Design cell name: TB_HDEMG_AFE_16
// Design view name: config
// Solver: Spectre

`include "disciplines.vams"
`include "userDisciplines.vams"
// HDL file - EMG_202009, DAC, verilogams.
// HDL file - EMG_202009, Counter_4bit, functional.
// HDL file - EMG_202009, ADC, verilogams.
// HDL file - EMG_202009, MUX_16, verilogams.
// HDL file - EMG_202009, VGA, verilogams.
// HDL file - EMG_202009, BPF, verilogams.
// HDL file - EMG_202009, IA, verilogams.
// Library - EMG_202009, Cell - Single_Channel, View - schematic
// LAST TIME SAVED: Sep 22 09:26:51 2020
// NETLIST TIME: Sep 28 16:34:01 2020

`worklib EMG_202009
`view schematic

`timescale 1ns / 1ps
(* cds_ams_schematic *)

module Single_Channel (Vout, Gain_Sel, Vdda, Vinn, Vinp, Vssa);
output  Vout;
input  Gain_Sel, Vdda, Vinn, Vinp, Vssa;
wire net15;
wire net17;
IA I0 (.Vout( net15 ), .Vdda( Vdda ), .Vinn( Vinn ), .Vinp( Vinp ), .Vssa( Vssa ));
BPF I1 (.Vout( net17 ), .Vdda( Vdda ), .Vin( net15 ), .Vssa( Vssa ));
VGA I2 (.Vout( Vout ), .Gain_Sel( Gain_Sel ), .Vdda( Vdda ), .Vin( net17 ), .Vssa( Vssa ));

endmodule
// Library - EMG_202009, Cell - MultiChannel_16, View - schematic
// LAST TIME SAVED: Sep 27 20:12:28 2020
// NETLIST TIME: Sep 28 16:34:01 2020

`worklib EMG_202009
`view schematic

`timescale 1ns / 1ps
(* cds_ams_schematic *)

module MultiChannel_16 (Vout_ch1, Vout_ch2, Vout_ch3, Vout_ch4, Vout_ch5, Vout_ch6, Vout_ch7, Vout_ch8, Vout_ch9, Vout_ch10, Vout_ch11, Vout_ch12, Vout_ch13, Vout_ch14, Vout_ch15, Vout_ch16, Gain_Sel, Vdda, Vinn_ch1, Vinn_ch2, Vinn_ch3, Vinn_ch4, Vinn_ch5, Vinn_ch6, Vinn_ch7, Vinn_ch8, Vinn_ch9, Vinn_ch10, Vinn_ch11, Vinn_ch12, Vinn_ch13, Vinn_ch14, Vinn_ch15, Vinn_ch16, Vinp_ch1, Vinp_ch2, Vinp_ch3, Vinp_ch4, Vinp_ch5, Vinp_ch6, Vinp_ch7, Vinp_ch8, Vinp_ch9, Vinp_ch10, Vinp_ch11, Vinp_ch12, Vinp_ch13, Vinp_ch14, Vinp_ch15, Vinp_ch16, Vssa);
output  Vout_ch1, Vout_ch2, Vout_ch3, Vout_ch4, Vout_ch5, Vout_ch6, Vout_ch7, Vout_ch8, Vout_ch9, Vout_ch10, Vout_ch11, Vout_ch12, Vout_ch13, Vout_ch14, Vout_ch15, Vout_ch16;
input  Gain_Sel, Vdda, Vinn_ch1, Vinn_ch2, Vinn_ch3, Vinn_ch4, Vinn_ch5, Vinn_ch6, Vinn_ch7, Vinn_ch8, Vinn_ch9, Vinn_ch10, Vinn_ch11, Vinn_ch12, Vinn_ch13, Vinn_ch14, Vinn_ch15, Vinn_ch16, Vinp_ch1, Vinp_ch2, Vinp_ch3, Vinp_ch4, Vinp_ch5, Vinp_ch6, Vinp_ch7, Vinp_ch8, Vinp_ch9, Vinp_ch10, Vinp_ch11, Vinp_ch12, Vinp_ch13, Vinp_ch14, Vinp_ch15, Vinp_ch16, Vssa;
Single_Channel I16 (.Vssa( Vssa ), .Vdda( Vdda ), .Vout( Vout_ch16 ), .Gain_Sel( Gain_Sel ), .Vinn( Vinn_ch16 ), .Vinp( Vinp_ch16 ));
Single_Channel I15 (.Vssa( Vssa ), .Vdda( Vdda ), .Vout( Vout_ch15 ), .Gain_Sel( Gain_Sel ), .Vinn( Vinn_ch15 ), .Vinp( Vinp_ch15 ));
Single_Channel I14 (.Vssa( Vssa ), .Vdda( Vdda ), .Vout( Vout_ch14 ), .Gain_Sel( Gain_Sel ), .Vinn( Vinn_ch14 ), .Vinp( Vinp_ch14 ));
Single_Channel I13 (.Vssa( Vssa ), .Vdda( Vdda ), .Vout( Vout_ch13 ), .Gain_Sel( Gain_Sel ), .Vinn( Vinn_ch13 ), .Vinp( Vinp_ch13 ));
Single_Channel I12 (.Vssa( Vssa ), .Vdda( Vdda ), .Vout( Vout_ch12 ), .Gain_Sel( Gain_Sel ), .Vinn( Vinn_ch12 ), .Vinp( Vinp_ch12 ));
Single_Channel I11 (.Vssa( Vssa ), .Vdda( Vdda ), .Vout( Vout_ch11 ), .Gain_Sel( Gain_Sel ), .Vinn( Vinn_ch11 ), .Vinp( Vinp_ch11 ));
Single_Channel I10 (.Vssa( Vssa ), .Vdda( Vdda ), .Vout( Vout_ch10 ), .Gain_Sel( Gain_Sel ), .Vinn( Vinn_ch10 ), .Vinp( Vinp_ch10 ));
Single_Channel I9 (.Vssa( Vssa ), .Vdda( Vdda ), .Vout( Vout_ch9 ), .Gain_Sel( Gain_Sel ), .Vinn( Vinn_ch9 ), .Vinp( Vinp_ch9 ));
Single_Channel I8 (.Vssa( Vssa ), .Vdda( Vdda ), .Vout( Vout_ch8 ), .Gain_Sel( Gain_Sel ), .Vinn( Vinn_ch8 ), .Vinp( Vinp_ch8 ));
Single_Channel I7 (.Vssa( Vssa ), .Vdda( Vdda ), .Vout( Vout_ch7 ), .Gain_Sel( Gain_Sel ), .Vinn( Vinn_ch7 ), .Vinp( Vinp_ch7 ));
Single_Channel I6 (.Vssa( Vssa ), .Vdda( Vdda ), .Vout( Vout_ch6 ), .Gain_Sel( Gain_Sel ), .Vinn( Vinn_ch6 ), .Vinp( Vinp_ch6 ));
Single_Channel I5 (.Vssa( Vssa ), .Vdda( Vdda ), .Vout( Vout_ch5 ), .Gain_Sel( Gain_Sel ), .Vinn( Vinn_ch5 ), .Vinp( Vinp_ch5 ));
Single_Channel I4 (.Vssa( Vssa ), .Vdda( Vdda ), .Vout( Vout_ch4 ), .Gain_Sel( Gain_Sel ), .Vinn( Vinn_ch4 ), .Vinp( Vinp_ch4 ));
Single_Channel I3 (.Vssa( Vssa ), .Vdda( Vdda ), .Vout( Vout_ch3 ), .Gain_Sel( Gain_Sel ), .Vinn( Vinn_ch3 ), .Vinp( Vinp_ch3 ));
Single_Channel I2 (.Vssa( Vssa ), .Vdda( Vdda ), .Vout( Vout_ch2 ), .Gain_Sel( Gain_Sel ), .Vinn( Vinn_ch2 ), .Vinp( Vinp_ch2 ));
Single_Channel I1 (.Vssa( Vssa ), .Vdda( Vdda ), .Vout( Vout_ch1 ), .Gain_Sel( Gain_Sel ), .Vinn( Vinn_ch1 ), .Vinp( Vinp_ch1 ));

endmodule
// Library - EMG_202009, Cell - TB_HDEMG_AFE_16, View - schematic
// LAST TIME SAVED: Sep 28 16:33:01 2020
// NETLIST TIME: Sep 28 16:34:01 2020

`worklib EMG_202009
`view schematic

`timescale 1ns / 1ps
(* cds_ams_schematic *)

module TB_HDEMG_AFE_16 ( );
wire [11:0] Dout;
wire [3:0] Sel;
wire Vinn_ch16;
wire Vinp_ch16;
wire Vinn_ch15;
wire Vinp_ch15;
wire Vinn_ch14;
wire Vinp_ch14;
wire Vinn_ch13;
wire Vinp_ch13;
wire Vinn_ch12;
wire Vinp_ch12;
wire Vinn_ch11;
wire Vinp_ch11;
wire Vinn_ch10;
wire Vinp_ch10;
wire Vinn_ch9;
wire Vinp_ch9;
wire Vinn_ch8;
wire Vinp_ch8;
wire Vinn_ch7;
wire Vinp_ch7;
wire Vinn_ch6;
wire Vinp_ch6;
wire Vinn_ch5;
wire Vinp_ch5;
wire Vinn_ch4;
wire Vinp_ch4;
wire Vinn_ch3;
wire Vinp_ch3;
wire Vinn_ch2;
wire Vinp_ch2;
wire Vinn_ch1;
wire Vinp_ch1;
wire Vout_ch16;
wire Vout_ch15;
wire Vout_ch14;
wire Vout_ch13;
wire Vout_ch12;
wire Vout_ch11;
wire Vout_ch10;
wire Vout_ch9;
wire Vout_ch8;
wire Vout_ch7;
wire Vout_ch6;
wire Vout_ch5;
wire Vout_ch4;
wire Vout_ch3;
wire Vout_ch2;
wire Vout_ch1;
wire Vdda;
wire CLK;
wire Mux_Out;
wire Vout;
MultiChannel_16 I0 (.Vssa(cds_globals.\gnd! ), .Vdda( Vdda ), .Vout_ch1( Vout_ch1 ), .Vout_ch2( Vout_ch2 ), .Vout_ch3( Vout_ch3 ), .Vout_ch4( Vout_ch4 ), .Vout_ch5( Vout_ch5 ), .Vout_ch6( Vout_ch6 ), .Vout_ch7( Vout_ch7 ), .Vout_ch8( Vout_ch8 ), .Vout_ch9( Vout_ch9 ), .Vout_ch10( Vout_ch10 ), .Vout_ch11( Vout_ch11 ), .Vout_ch12( Vout_ch12 ), .Vout_ch13( Vout_ch13 ), .Vout_ch14( Vout_ch14 ), .Vout_ch15( Vout_ch15 ), .Vout_ch16( Vout_ch16 ), .Gain_Sel(cds_globals.\gnd! ), .Vinp_ch1( Vinp_ch1 ), .Vinn_ch1( Vinn_ch1 ), .Vinp_ch2( Vinp_ch2 ), .Vinn_ch2( Vinn_ch2 ), .Vinp_ch3( Vinp_ch3 ), .Vinn_ch3( Vinn_ch3 ), .Vinp_ch4( Vinp_ch4 ), .Vinn_ch4( Vinn_ch4 ), .Vinp_ch5( Vinp_ch5 ), .Vinn_ch5( Vinn_ch5 ), .Vinp_ch6( Vinp_ch6 ), .Vinn_ch6( Vinn_ch6 ), .Vinp_ch7( Vinp_ch7 ), .Vinn_ch7( Vinn_ch7 ), .Vinp_ch8( Vinp_ch8 ), .Vinn_ch8( Vinn_ch8 ), .Vinp_ch9( Vinp_ch9 ), .Vinn_ch9( Vinn_ch9 ), .Vinp_ch10( Vinp_ch10 ), .Vinn_ch10( Vinn_ch10 ), .Vinp_ch11( Vinp_ch11 ), .Vinn_ch11( Vinn_ch11 ), .Vinp_ch12( Vinp_ch12 ), .Vinn_ch12( Vinn_ch12 ), .Vinp_ch13( Vinp_ch13 ), .Vinn_ch13( Vinn_ch13 ), .Vinp_ch14( Vinp_ch14 ), .Vinn_ch14( Vinn_ch14 ), .Vinp_ch15( Vinp_ch15 ), .Vinn_ch15( Vinn_ch15 ), .Vinp_ch16( Vinp_ch16 ), .Vinn_ch16( Vinn_ch16 ));
MUX_16 I42 (.Vout( Mux_Out ), .Clk( CLK ), .Vdda( Vdda ), .Vin0( Vout_ch1 ), .Vin1( Vout_ch2 ), .Vin2( Vout_ch3 ), .Vin3( Vout_ch4 ), .Vin4( Vout_ch5 ), .Vin5( Vout_ch6 ), .Vin6( Vout_ch7 ), .Vin7( Vout_ch8 ), .Vin8( Vout_ch9 ), .Vin9( Vout_ch10 ), .Vin10( Vout_ch11 ), .Vin11( Vout_ch12 ), .Vin12( Vout_ch13 ), .Vin13( Vout_ch14 ), .Vin14( Vout_ch15 ), .Vin15( Vout_ch16 ), .Vssa(cds_globals.\gnd! ), .sel( Sel ));
ADC #(.thresh(0.9)) I2 (.Dout( Dout ), .Clk( CLK ), .Vdda( Vdda ), .Vin( Mux_Out ), .Vssa(cds_globals.\gnd! ));
Counter_4bit I38 (.Q( Sel ), .Clk( CLK ), .Reset(cds_globals.\gnd! ));
DAC #(.thresh(0.9)) I39 (.Din( Dout ), .Vout( Vout ), .Clk( CLK ), .Vdda( Vdda ), .Vssa(cds_globals.\gnd! ));
vcvs #(.gain(0.5)) E31 (Vinp_ch16, net054, Vsig_ch16, cds_globals.\gnd! );
vcvs #(.gain(-0.5)) E30 (Vinn_ch15, net055, Vsig_ch15, cds_globals.\gnd! );
vcvs #(.gain(0.5)) E29 (Vinp_ch15, net055, Vsig_ch15, cds_globals.\gnd! );
vcvs #(.gain(-0.5)) E28 (Vinn_ch16, net054, Vsig_ch16, cds_globals.\gnd! );
vcvs #(.gain(0.5)) E27 (Vinp_ch14, net056, Vsig_ch14, cds_globals.\gnd! );
vcvs #(.gain(-0.5)) E26 (Vinn_ch13, net057, Vsig_ch13, cds_globals.\gnd! );
vcvs #(.gain(0.5)) E25 (Vinp_ch13, net057, Vsig_ch13, cds_globals.\gnd! );
vcvs #(.gain(-0.5)) E24 (Vinn_ch14, net056, Vsig_ch14, cds_globals.\gnd! );
vcvs #(.gain(0.5)) E23 (Vinp_ch12, net038, Vsig_ch12, cds_globals.\gnd! );
vcvs #(.gain(-0.5)) E22 (Vinn_ch11, net039, Vsig_ch11, cds_globals.\gnd! );
vcvs #(.gain(0.5)) E21 (Vinp_ch11, net039, Vsig_ch11, cds_globals.\gnd! );
vcvs #(.gain(-0.5)) E20 (Vinn_ch12, net038, Vsig_ch12, cds_globals.\gnd! );
vcvs #(.gain(0.5)) E19 (Vinp_ch10, net040, Vsig_ch10, cds_globals.\gnd! );
vcvs #(.gain(-0.5)) E18 (Vinn_ch9, net041, Vsig_ch9, cds_globals.\gnd! );
vcvs #(.gain(0.5)) E17 (Vinp_ch9, net041, Vsig_ch9, cds_globals.\gnd! );
vcvs #(.gain(-0.5)) E16 (Vinn_ch10, net040, Vsig_ch10, cds_globals.\gnd! );
vcvs #(.gain(0.5)) E15 (Vinp_ch8, net022, Vsig_ch8, cds_globals.\gnd! );
vcvs #(.gain(-0.5)) E14 (Vinn_ch7, net023, Vsig_ch7, cds_globals.\gnd! );
vcvs #(.gain(0.5)) E13 (Vinp_ch7, net023, Vsig_ch7, cds_globals.\gnd! );
vcvs #(.gain(-0.5)) E12 (Vinn_ch8, net022, Vsig_ch8, cds_globals.\gnd! );
vcvs #(.gain(0.5)) E11 (Vinp_ch6, net024, Vsig_ch6, cds_globals.\gnd! );
vcvs #(.gain(-0.5)) E10 (Vinn_ch5, net025, Vsig_ch5, cds_globals.\gnd! );
vcvs #(.gain(0.5)) E9 (Vinp_ch5, net025, Vsig_ch5, cds_globals.\gnd! );
vcvs #(.gain(-0.5)) E8 (Vinn_ch6, net024, Vsig_ch6, cds_globals.\gnd! );
vcvs #(.gain(0.5)) E7 (Vinp_ch4, net05, Vsig_ch4, cds_globals.\gnd! );
vcvs #(.gain(-0.5)) E6 (Vinn_ch3, net06, Vsig_ch3, cds_globals.\gnd! );
vcvs #(.gain(0.5)) E5 (Vinp_ch3, net06, Vsig_ch3, cds_globals.\gnd! );
vcvs #(.gain(-0.5)) E4 (Vinn_ch4, net05, Vsig_ch4, cds_globals.\gnd! );
vcvs #(.gain(0.5)) E3 (Vinp_ch2, net07, Vsig_ch2, cds_globals.\gnd! );
vcvs #(.gain(-0.5)) E1 (Vinn_ch1, net2, Vsig_ch1, cds_globals.\gnd! );
vcvs #(.gain(0.5)) E0 (Vinp_ch1, net2, Vsig_ch1, cds_globals.\gnd! );
vcvs #(.gain(-0.5)) E2 (Vinn_ch2, net07, Vsig_ch2, cds_globals.\gnd! );
vsource #(.type("sine"), .delay((1/(100*16))*14), .ampl(0.005), .freq(100)) V29 (Vsig_ch15, cds_globals.\gnd! );
vsource #(.type("sine"), .delay((1/(100*16))*15), .ampl(0.005), .freq(100)) V28 (Vsig_ch16, cds_globals.\gnd! );
vsource #(.type("sine"), .delay((1/(100*16))*12), .ampl(0.005), .freq(100)) V25 (Vsig_ch13, cds_globals.\gnd! );
vsource #(.type("sine"), .delay((1/(100*16))*13), .ampl(0.005), .freq(100)) V24 (Vsig_ch14, cds_globals.\gnd! );
vsource #(.type("sine"), .delay((1/(100*16))*10), .ampl(0.005), .freq(100)) V21 (Vsig_ch11, cds_globals.\gnd! );
vsource #(.type("sine"), .delay((1/(100*16))*11), .ampl(0.005), .freq(100)) V20 (Vsig_ch12, cds_globals.\gnd! );
vsource #(.type("sine"), .delay((1/(100*16))*8), .ampl(0.005), .freq(100)) V17 (Vsig_ch9, cds_globals.\gnd! );
vsource #(.type("sine"), .delay((1/(100*16))*9), .ampl(0.005), .freq(100)) V16 (Vsig_ch10, cds_globals.\gnd! );
vsource #(.type("sine"), .delay((1/(100*16))*6), .ampl(0.005), .freq(100)) V13 (Vsig_ch7, cds_globals.\gnd! );
vsource #(.type("sine"), .delay((1/(100*16))*7), .ampl(0.005), .freq(100)) V12 (Vsig_ch8, cds_globals.\gnd! );
vsource #(.type("sine"), .delay((1/(100*16))*4), .ampl(0.005), .freq(100)) V9 (Vsig_ch5, cds_globals.\gnd! );
vsource #(.type("sine"), .delay((1/(100*16))*5), .ampl(0.005), .freq(100)) V8 (Vsig_ch6, cds_globals.\gnd! );
vsource #(.type("sine"), .delay((1/(100*16))*2), .ampl(0.005), .freq(100)) V5 (Vsig_ch3, cds_globals.\gnd! );
vsource #(.type("sine"), .delay((1/(100*16))*3), .ampl(0.005), .freq(100)) V4 (Vsig_ch4, cds_globals.\gnd! );
vsource #(.type("sine"), .delay((1/(100*16))*0), .ampl(0.005), .freq(100)) V0 (Vsig_ch1, cds_globals.\gnd! );
vsource #(.type("sine"), .delay((1/(100*16))*1), .ampl(0.005), .freq(100)) V2 (Vsig_ch2, cds_globals.\gnd! );
vsource #(.type("pulse"), .val0(0), .val1(1.8), .period(1/(32e+3)), .delay(1/(32e+3*2)), .rise(1e-11), .fall(1e-11), .width(1/(32e+3*2))) V33 (CLK, cds_globals.\gnd! );
vsource #(.dc(1.8), .type("dc")) V32 (Vdda, cds_globals.\gnd! );
vsource #(.dc(cds_globals.Vcm), .type("dc")) V31 (net055, cds_globals.\gnd! );
vsource #(.dc(cds_globals.Vcm), .type("dc")) V30 (net054, cds_globals.\gnd! );
vsource #(.dc(cds_globals.Vcm), .type("dc")) V27 (net057, cds_globals.\gnd! );
vsource #(.dc(cds_globals.Vcm), .type("dc")) V26 (net056, cds_globals.\gnd! );
vsource #(.dc(cds_globals.Vcm), .type("dc")) V23 (net039, cds_globals.\gnd! );
vsource #(.dc(cds_globals.Vcm), .type("dc")) V22 (net038, cds_globals.\gnd! );
vsource #(.dc(cds_globals.Vcm), .type("dc")) V19 (net041, cds_globals.\gnd! );
vsource #(.dc(cds_globals.Vcm), .type("dc")) V18 (net040, cds_globals.\gnd! );
vsource #(.dc(cds_globals.Vcm), .type("dc")) V15 (net023, cds_globals.\gnd! );
vsource #(.dc(cds_globals.Vcm), .type("dc")) V14 (net022, cds_globals.\gnd! );
vsource #(.dc(cds_globals.Vcm), .type("dc")) V11 (net025, cds_globals.\gnd! );
vsource #(.dc(cds_globals.Vcm), .type("dc")) V10 (net024, cds_globals.\gnd! );
vsource #(.dc(cds_globals.Vcm), .type("dc")) V7 (net06, cds_globals.\gnd! );
vsource #(.dc(cds_globals.Vcm), .type("dc")) V6 (net05, cds_globals.\gnd! );
vsource #(.dc(cds_globals.Vcm), .type("dc")) V1 (net2, cds_globals.\gnd! );
vsource #(.dc(cds_globals.Vcm), .type("dc")) V3 (net07, cds_globals.\gnd! );

endmodule
`noworklib
`noview
