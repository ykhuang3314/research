// AMS netlist generated by the AMS Unified netlister
// IC subversion:  IC6.1.8-64b.500.7
// Xcelium version: 18.03-s018
// Copyright(C) 2005-2009, Cadence Design Systems, Inc
// User: ykhuang Pid: 32262
// Design library name: Stimulator_TestBench
// Design cell name: TB_ChannelSelection_imp
// Design view name: config
// Solver: Spectre

`include "disciplines.vams"
`include "userDisciplines.vams"
// HDL file - Stimulator_IMP, Digital_Stimulus_V2_ST, functional.
// HDL file - Stimulator_IMP, Decoder8, functional.
// Library - Stimulator_IMP, Cell - LS_HighSide_V3_ST, View - schematic
// LAST TIME SAVED: Mar 19 17:27:00 2021
// NETLIST TIME: Apr  5 11:42:26 2021

`worklib Stimulator_IMP
`view schematic

`timescale 1ns / 1ps
(* cds_ams_schematic *)

module LS_HighSide_V3_ST (out, .\gnd! (cdsNet2), .\vdd3! (cdsNet1), .\vdde! (cdsNet0), vddh, in);
output  out;
input  in;
inout  cdsNet2, cdsNet1, cdsNet0, vddh;
wire inn3v;
cds_alias #(1) cds_alias_inst1 ( cdsNet2 , cds_globals.\gnd! );
cds_alias #(1) cds_alias_inst2 ( cdsNet1 , cds_globals.\vdd3! );
cds_alias #(1) cds_alias_inst3 ( cdsNet0 , cds_globals.\vdde! );
LSHVT18U3VX1 I10 (.A( in ), .Q( inn3v ));
nedia_bjt #(.w(1e-05), .l(1.25e-06), .m((1)*(5)), .par1((1)*(5)), .extlay(0), .xf_subext(0))
(* integer passed_mfactor = "m"; *)
 M13 (net10, inn3v, cds_globals.\gnd! , cds_globals.\gnd! );
rpp1k1 #(.l(0.00030447), .w(2e-06), .m(1), .par1(1))
(* integer passed_mfactor = "m"; *)
 R0 (vddh, out);
rpp1k1 #(.l(0.000507595), .w(2e-06), .m(1), .par1(1))
(* integer passed_mfactor = "m"; *)
 R1 (out, net10);

endmodule
// Library - Stimulator_IMP, Cell - Idac_5bit_ST, View - schematic
// LAST TIME SAVED: Mar 31 15:05:20 2021
// NETLIST TIME: Apr  5 11:42:26 2021

`worklib Stimulator_IMP
`view schematic

`timescale 1ns / 1ps
(* cds_ams_schematic *)

module Idac_5bit_ST (Idac, vdd3, Bias1, Bias2, D0, D1, D2, D3, D4, Enable);
output  Idac;
input  Bias1, Bias2, D0, D1, D2, D3, D4, Enable;
inout  vdd3;
wire net020;
wire net024;
wire net019;
wire net021;
wire net018;
wire net022;
wire net017;
wire net023;
wire net025;
wire net026;
wire D0_3v;
wire D1_3v;
wire D2_3v;
wire D3_3v;
wire D4_3v;
LSHVT18U3VX1 I16 (.A( net024 ), .Q( net020 ));
LSHVT18U3VX1 I30 (.A( net021 ), .Q( net019 ));
LSHVT18U3VX1 I14 (.A( net022 ), .Q( net018 ));
LSHVT18U3VX1 I12 (.A( net023 ), .Q( net017 ));
LSHVT18U3VX1 I29 (.A( net026 ), .Q( net025 ));
IN_3VX2 I31 (.A( net020 ), .Q( D0_3v ));
IN_3VX2 I15 (.A( net019 ), .Q( D1_3v ));
IN_3VX2 I13 (.A( net018 ), .Q( D2_3v ));
IN_3VX2 I11 (.A( net017 ), .Q( D3_3v ));
IN_3VX2 I10 (.A( net025 ), .Q( D4_3v ));
AND2HDX0 I45 (.Q( net024 ), .B( D0 ), .A( Enable ));
AND2HDX0 I46 (.Q( net021 ), .B( D1 ), .A( Enable ));
AND2HDX0 I47 (.Q( net022 ), .B( D2 ), .A( Enable ));
AND2HDX0 I48 (.Q( net023 ), .B( D3 ), .A( Enable ));
AND2HDX0 I49 (.Q( net026 ), .B( D4 ), .A( Enable ));
pe3 #(.w(1e-05), .l(1e-06), .as(2.9625e-12), .ad(2.7e-12), .ps(1.18425e-05), .pd(1.054e-05), .nrs(0.027), .nrd(0.027), .m((1)*(16)), .par1((1)*(16)))
(* integer passed_mfactor = "m"; *)
 M41 (net31, Bias1, vdd3, vdd3);
pe3 #(.w(1e-05), .l(1e-06), .as(3.225e-12), .ad(2.7e-12), .ps(1.3145e-05), .pd(1.054e-05), .nrs(0.027), .nrd(0.027), .m((1)*(8)), .par1((1)*(8)))
(* integer passed_mfactor = "m"; *)
 M38 (net33, Bias1, vdd3, vdd3);
pe3 #(.w(1e-05), .l(1e-06), .as(3.75e-12), .ad(2.7e-12), .ps(1.575e-05), .pd(1.054e-05), .nrs(0.027), .nrd(0.027), .m((1)*(4)), .par1((1)*(4)))
(* integer passed_mfactor = "m"; *)
 M35 (net35, Bias1, vdd3, vdd3);
pe3 #(.w(1e-05), .l(1e-06), .as(4.8e-12), .ad(2.7e-12), .ps(2.096e-05), .pd(1.054e-05), .nrs(0.027), .nrd(0.027), .m((1)*(2)), .par1((1)*(2)))
(* integer passed_mfactor = "m"; *)
 M32 (net37, Bias1, vdd3, vdd3);
pe3 #(.w(1e-05), .l(1e-06), .as(4.8e-12), .ad(4.8e-12), .ps(2.096e-05), .pd(2.096e-05), .nrs(0.027), .nrd(0.027), .m((1)*(1)), .par1((1)*(1)))
(* integer passed_mfactor = "m"; *)
 M22 (net39, Bias1, vdd3, vdd3);
pe3 #(.w(1e-05), .l(1e-06), .as(2.9625e-12), .ad(2.7e-12), .ps(1.18425e-05), .pd(1.054e-05), .nrs(0.027), .nrd(0.027), .m((1)*(16)), .par1((1)*(16)))
(* integer passed_mfactor = "m"; *)
 M42 (net30, Bias2, net31, vdd3);
pe3 #(.w(1e-05), .l(1e-06), .as(3.225e-12), .ad(2.7e-12), .ps(1.3145e-05), .pd(1.054e-05), .nrs(0.027), .nrd(0.027), .m((1)*(8)), .par1((1)*(8)))
(* integer passed_mfactor = "m"; *)
 M39 (net32, Bias2, net33, vdd3);
pe3 #(.w(1e-05), .l(1e-06), .as(3.75e-12), .ad(2.7e-12), .ps(1.575e-05), .pd(1.054e-05), .nrs(0.027), .nrd(0.027), .m((1)*(4)), .par1((1)*(4)))
(* integer passed_mfactor = "m"; *)
 M36 (net34, Bias2, net35, vdd3);
pe3 #(.w(1e-05), .l(1e-06), .as(4.8e-12), .ad(2.7e-12), .ps(2.096e-05), .pd(1.054e-05), .nrs(0.027), .nrd(0.027), .m((1)*(2)), .par1((1)*(2)))
(* integer passed_mfactor = "m"; *)
 M33 (net36, Bias2, net37, vdd3);
pe3 #(.w(1e-05), .l(1e-06), .as(4.8e-12), .ad(4.8e-12), .ps(2.096e-05), .pd(2.096e-05), .nrs(0.027), .nrd(0.027), .m((1)*(1)), .par1((1)*(1)))
(* integer passed_mfactor = "m"; *)
 M29 (net38, Bias2, net39, vdd3);
pe3 #(.w(1e-05), .l(3e-07), .as(4.8e-12), .ad(4.8e-12), .ps(2.096e-05), .pd(2.096e-05), .nrs(0.027), .nrd(0.027), .m((1)*(1)), .par1((1)*(1)))
(* integer passed_mfactor = "m"; *)
 M44 (Idac, D1_3v, net36, vdd3);
pe3 #(.w(1e-05), .l(3e-07), .as(4.8e-12), .ad(4.8e-12), .ps(2.096e-05), .pd(2.096e-05), .nrs(0.027), .nrd(0.027), .m((1)*(1)), .par1((1)*(1)))
(* integer passed_mfactor = "m"; *)
 M45 (Idac, D2_3v, net34, vdd3);
pe3 #(.w(1e-05), .l(3e-07), .as(4.8e-12), .ad(4.8e-12), .ps(2.096e-05), .pd(2.096e-05), .nrs(0.027), .nrd(0.027), .m((1)*(1)), .par1((1)*(1)))
(* integer passed_mfactor = "m"; *)
 M46 (Idac, D3_3v, net32, vdd3);
pe3 #(.w(1e-05), .l(3e-07), .as(4.8e-12), .ad(4.8e-12), .ps(2.096e-05), .pd(2.096e-05), .nrs(0.027), .nrd(0.027), .m((1)*(1)), .par1((1)*(1)))
(* integer passed_mfactor = "m"; *)
 M47 (Idac, D4_3v, net30, vdd3);
pe3 #(.w(1e-05), .l(3e-07), .as(4.8e-12), .ad(4.8e-12), .ps(2.096e-05), .pd(2.096e-05), .nrs(0.027), .nrd(0.027), .m((1)*(1)), .par1((1)*(1)))
(* integer passed_mfactor = "m"; *)
 M31 (Idac, D0_3v, net38, vdd3);

endmodule
// Library - Stimulator_IMP, Cell - CurrentMirror_ST, View - schematic
// LAST TIME SAVED: Apr  1 15:37:28 2021
// NETLIST TIME: Apr  5 11:42:26 2021

`worklib Stimulator_IMP
`view schematic

`timescale 1ns / 1ps
(* cds_ams_schematic *)

module CurrentMirror_ST (Iref, Ist, vdd3, vddh, vss, enable);
input  enable;
inout  Iref, Ist, vdd3, vddh, vss;
wire en_3v;
LSHVT18U3VX2 I17 (.A( enable ), .Q( en_3v ));
csft5a #(.area(6.3936e-11), .perimeter(3.372e-05), .m(15), .par1(15))
(* integer passed_mfactor = "m"; *)
 C5 (vddh, net014);
csft5a #(.area(6.3936e-11), .perimeter(3.372e-05), .m(45), .par1(45))
(* integer passed_mfactor = "m"; *)
 C1 (net014, vss);
ne3 #(.w(4e-05), .l(2e-06), .as(1.92e-11), .ad(1.92e-11), .ps(8.096e-05), .pd(8.096e-05), .nrs(0.00675), .nrd(0.00675), .m((1)*(1)), .par1((1)*(1)), .xf_subext(0))
(* integer passed_mfactor = "m"; *)
 M26 (Iref, Iref, vss, vss);
ne3 #(.w(4e-05), .l(2e-06), .as(1.248e-11), .ad(1.08e-11), .ps(4.8624e-05), .pd(4.054e-05), .nrs(0.00675), .nrd(0.00675), .m((1)*(10)), .par1((1)*(10)), .xf_subext(0))
(* integer passed_mfactor = "m"; *)
 M13 (net11, Iref, vss, vss);
nedia_bjt #(.w(1e-05), .l(1.25e-06), .m((1)*(1)), .par1((1)*(1)), .extlay(0), .xf_subext(0))
(* integer passed_mfactor = "m"; *)
 M17 (net11, net014, vss, vss);
nedia_bjt #(.w(1e-05), .l(1.25e-06), .m((1)*(1)), .par1((1)*(1)), .extlay(0), .xf_subext(0))
(* integer passed_mfactor = "m"; *)
 M15 (net014, vdd3, vss, vss);
nedia_bjt #(.w(3e-05), .l(1.25e-06), .m((1)*(1)), .par1((1)*(1)), .extlay(0), .xf_subext(0))
(* integer passed_mfactor = "m"; *)
 M14 (net016, net016, net19, vss);
nedia_bjt #(.w(6e-05), .l(1.25e-06), .m((1)*(1)), .par1((1)*(1)), .extlay(0), .xf_subext(0))
(* integer passed_mfactor = "m"; *)
 M8 (net17, net17, VB, vss);
nedia_bjt #(.w(6e-05), .l(1.25e-06), .m((1)*(5)), .par1((1)*(5)), .extlay(0), .xf_subext(0))
(* integer passed_mfactor = "m"; *)
 M16 (Bias2, en_3v, net11, vss);
nedia_bjt #(.w(6e-05), .l(1.25e-06), .m((1)*(1)), .par1((1)*(1)), .extlay(0), .xf_subext(0))
(* integer passed_mfactor = "m"; *)
 M5 (net19, VB, net26, vss);
nedia_bjt #(.w(6e-05), .l(1.25e-06), .m((1)*(10)), .par1((1)*(10)), .extlay(0), .xf_subext(0))
(* integer passed_mfactor = "m"; *)
 M0 (Ist, VB, net25, vss);
nedia_bjt #(.w(2e-05), .l(1.25e-06), .m((1)*(1)), .par1((1)*(1)), .extlay(0), .xf_subext(0))
(* integer passed_mfactor = "m"; *)
 M7 (VB, net17, net16, vss);
nedia_bjt #(.w(6e-05), .l(1.25e-06), .m((1)*(1)), .par1((1)*(1)), .extlay(0), .xf_subext(0))
(* integer passed_mfactor = "m"; *)
 M6 (net16, net16, vss, vss);
nedia_bjt #(.w(6e-05), .l(1.25e-06), .m((1)*(1)), .par1((1)*(1)), .extlay(0), .xf_subext(0))
(* integer passed_mfactor = "m"; *)
 M4 (net26, net19, vss, vss);
nedia_bjt #(.w(6e-05), .l(1.25e-06), .m((1)*(10)), .par1((1)*(10)), .extlay(0), .xf_subext(0))
(* integer passed_mfactor = "m"; *)
 M3 (net25, net19, vss, vss);
ped_bjt #(.w(3e-05), .l(9.4e-07), .m((1)*(1)), .par1((1)*(1)), .extlay(0), .xf_subext(0))
(* integer passed_mfactor = "m"; *)
 M11 (net23, net013, vddh, vss);
ped_bjt #(.w(3e-05), .l(9.4e-07), .m((1)*(1)), .par1((1)*(1)), .extlay(0), .xf_subext(0))
(* integer passed_mfactor = "m"; *)
 M1 (net24, net013, vddh, vss);
ped_bjt #(.w(3e-05), .l(9.4e-07), .m((1)*(1)), .par1((1)*(1)), .extlay(0), .xf_subext(0))
(* integer passed_mfactor = "m"; *)
 M2 (net013, net013, vddh, vss);
ped_bjt #(.w(3e-05), .l(9.4e-07), .m((1)*(1)), .par1((1)*(1)), .extlay(0), .xf_subext(0))
(* integer passed_mfactor = "m"; *)
 M12 (net016, Bias2, net23, vss);
ped_bjt #(.w(3e-05), .l(9.4e-07), .m((1)*(1)), .par1((1)*(1)), .extlay(0), .xf_subext(0))
(* integer passed_mfactor = "m"; *)
 M10 (net17, Bias2, net24, vss);
ped_bjt #(.w(3e-05), .l(9.4e-07), .m((1)*(1)), .par1((1)*(1)), .extlay(0), .xf_subext(0))
(* integer passed_mfactor = "m"; *)
 M9 (Bias2, Bias2, net013, vss);
rpp1k1 #(.l(0.000202905), .w(2e-06), .m(1), .par1(1))
(* integer passed_mfactor = "m"; *)
 R1 (vdd3, vss);
rpp1k1 #(.l(0.000202905), .w(2e-06), .m(1), .par1(1))
(* integer passed_mfactor = "m"; *)
 R0 (en_3v, vss);

endmodule
// Library - Stimulator_IMP, Cell - CurrentSource_All_ST, View - schematic
// LAST TIME SAVED: Apr  1 15:53:40 2021
// NETLIST TIME: Apr  5 11:42:26 2021

`worklib Stimulator_IMP
`view schematic

`timescale 1ns / 1ps
(* cds_ams_schematic *)

module CurrentSource_All_ST (Iext, Ist, vdd3, vddh, vss, Enable_ST, Mag0_ST, Mag1_ST, Mag2_ST, Mag3_ST, Mag4_ST);
input  Enable_ST, Mag0_ST, Mag1_ST, Mag2_ST, Mag3_ST, Mag4_ST;
inout  Iext, Ist, vdd3, vddh, vss;
wire Bias2;
wire Bias1;
wire net9;
Ext_Iref_ST I0 (.Iext( Iext ), .vdd3( vdd3 ), .vss( vss ), .Bias1( Bias1 ), .Bias2( Bias2 ));
Idac_5bit_ST I1 (.Enable( Enable_ST ), .Idac( net9 ), .vdd3( vdd3 ), .Bias1( Bias1 ), .Bias2( Bias2 ), .D0( Mag0_ST ), .D1( Mag1_ST ), .D2( Mag2_ST ), .D3( Mag3_ST ), .D4( Mag4_ST ));
CurrentMirror_ST I2 (.vss( vss ), .Ist( Ist ), .Iref( net9 ), .vddh( vddh ), .vdd3( vdd3 ), .enable( Enable_ST ));

endmodule
// Library - Stimulator_IMP, Cell - LS_LowSide_V2_ST, View - schematic
// LAST TIME SAVED: Mar 23 11:40:23 2021
// NETLIST TIME: Apr  5 11:42:26 2021

`worklib Stimulator_IMP
`view schematic

`timescale 1ns / 1ps
(* cds_ams_schematic *)

module LS_LowSide_V2_ST (out, .\gnd! (cdsNet2), .\vdd3! (cdsNet1), .\vdde! (cdsNet0), vddh, in);
output  out;
input  in;
inout  cdsNet2, cdsNet1, cdsNet0, vddh;
wire in_3V;
cds_alias #(1) cds_alias_inst4 ( cdsNet2 , cds_globals.\gnd! );
cds_alias #(1) cds_alias_inst5 ( cdsNet1 , cds_globals.\vdd3! );
cds_alias #(1) cds_alias_inst6 ( cdsNet0 , cds_globals.\vdde! );
LSHVT18U3VX1 I0 (.A( in ), .Q( in_3V ));
nedia_bjt #(.w(3e-05), .l(1.25e-06), .m((1)*(1)), .par1((1)*(1)), .extlay(0), .xf_subext(0))
(* integer passed_mfactor = "m"; *)
 M0 (net12, in_3V, cds_globals.\gnd! , cds_globals.\gnd! );
rpp1k1 #(.l(0.000507595), .w(2e-06), .m(1), .par1(1))
(* integer passed_mfactor = "m"; *)
 R2 (net9, net12);
rpp1k1 #(.l(0.00030447), .w(2e-06), .m(1), .par1(1))
(* integer passed_mfactor = "m"; *)
 R0 (out, cds_globals.\gnd! );
rpp1k1 #(.l(0.00030447), .w(2e-06), .m(1), .par1(1))
(* integer passed_mfactor = "m"; *)
 R1 (vddh, net9);
rpp1k1 #(.l(0.000507595), .w(2e-06), .m(1), .par1(1))
(* integer passed_mfactor = "m"; *)
 R3 (net11, out);
ped_bjt #(.w(3e-05), .l(9.4e-07), .m((1)*(1)), .par1((1)*(1)), .extlay(0), .xf_subext(0))
(* integer passed_mfactor = "m"; *)
 M1 (net11, net9, vddh, cds_globals.\gnd! );

endmodule
// Library - Stimulator_IMP, Cell - HalfBridge_ST, View - schematic
// LAST TIME SAVED: Mar 30 17:29:00 2021
// NETLIST TIME: Apr  5 11:42:26 2021

`worklib Stimulator_IMP
`view schematic

`timescale 1ns / 1ps
(* cds_ams_schematic *)

module HalfBridge_ST (OUT, Ist, .\gnd! (cdsNet2), .\vdd3! (cdsNet1), .\vdde! (cdsNet0), vddh, Ctrl_HS, Ctrl_LS);
output  OUT;
input  Ctrl_HS, Ctrl_LS;
inout  Ist, cdsNet2, cdsNet1, cdsNet0, vddh;
wire net07;
wire net08;
cds_alias #(1) cds_alias_inst7 ( cdsNet2 , cds_globals.\gnd! );
cds_alias #(1) cds_alias_inst8 ( cdsNet1 , cds_globals.\vdd3! );
cds_alias #(1) cds_alias_inst9 ( cdsNet0 , cds_globals.\vdde! );
LS_HighSide_V3_ST I8 (.\vdde! (cds_globals.\vdde! ), .\gnd! (cds_globals.\gnd! ), .\vdd3! (cds_globals.\vdd3! ), .vddh( vddh ), .out( net07 ), .in( Ctrl_HS ));
LS_LowSide_V2_ST I9 (.\gnd! (cds_globals.\gnd! ), .\vdd3! (cds_globals.\vdd3! ), .\vdde! (cds_globals.\vdde! ), .vddh( vddh ), .out( net08 ), .in( Ctrl_LS ));
nedia_bjt #(.w(0.0001), .l(1.25e-06), .m((1)*(6)), .par1((1)*(6)), .extlay(0), .xf_subext(0))
(* integer passed_mfactor = "m"; *)
 M34 (OUT, net08, Ist, cds_globals.\gnd! );
ped_bjt #(.w(0.0001), .l(9.4e-07), .m((1)*(6)), .par1((1)*(6)), .extlay(0), .xf_subext(0))
(* integer passed_mfactor = "m"; *)
 M66 (OUT, net07, vddh, cds_globals.\gnd! );

endmodule
// Library - Stimulator_IMP, Cell - Ext_Iref_ST, View - schematic
// LAST TIME SAVED: Mar 31 11:16:25 2021
// NETLIST TIME: Apr  5 11:42:26 2021

`worklib Stimulator_IMP
`view schematic

`timescale 1ns / 1ps
(* cds_ams_schematic *)

module Ext_Iref_ST (Bias1, Bias2, Iext, vdd3, vss);
output  Bias1, Bias2;
inout  Iext, vdd3, vss;
rpp1k1 #(.l(2.0095e-05), .w(2e-06), .m(1), .par1(1))
(* integer passed_mfactor = "m"; *)
 R0 (Iext, net9);
ne3 #(.w(2e-05), .l(1e-06), .as(9.6e-12), .ad(9.6e-12), .ps(4.096e-05), .pd(4.096e-05), .nrs(0.0135), .nrd(0.0135), .m((1)*(1)), .par1((1)*(1)), .xf_subext(0))
(* integer passed_mfactor = "m"; *)
 M3 (net8, net8, vss, vss);
ne3 #(.w(2e-05), .l(1e-06), .as(9.6e-12), .ad(9.6e-12), .ps(4.096e-05), .pd(4.096e-05), .nrs(0.0135), .nrd(0.0135), .m((1)*(1)), .par1((1)*(1)), .xf_subext(0))
(* integer passed_mfactor = "m"; *)
 M2 (net9, net9, net8, vss);
ne3 #(.w(2e-05), .l(1e-06), .as(9.6e-12), .ad(9.6e-12), .ps(4.096e-05), .pd(4.096e-05), .nrs(0.0135), .nrd(0.0135), .m((1)*(1)), .par1((1)*(1)), .xf_subext(0))
(* integer passed_mfactor = "m"; *)
 M0 (Bias2, net9, net17, vss);
ne3 #(.w(2e-05), .l(1e-06), .as(9.6e-12), .ad(9.6e-12), .ps(4.096e-05), .pd(4.096e-05), .nrs(0.0135), .nrd(0.0135), .m((1)*(1)), .par1((1)*(1)), .xf_subext(0))
(* integer passed_mfactor = "m"; *)
 M1 (net17, net8, vss, vss);
pe3 #(.w(1e-05), .l(1e-06), .as(4.8e-12), .ad(4.8e-12), .ps(2.096e-05), .pd(2.096e-05), .nrs(0.027), .nrd(0.027), .m((1)*(1)), .par1((1)*(1)))
(* integer passed_mfactor = "m"; *)
 M48 (Bias1, Bias1, vdd3, vdd3);
pe3 #(.w(1e-05), .l(1e-06), .as(4.8e-12), .ad(4.8e-12), .ps(2.096e-05), .pd(2.096e-05), .nrs(0.027), .nrd(0.027), .m((1)*(1)), .par1((1)*(1)))
(* integer passed_mfactor = "m"; *)
 M49 (Bias2, Bias2, Bias1, vdd3);

endmodule
// Library - GATES_3V, Cell - invrv3, View - schematic
// LAST TIME SAVED: Mar  7 12:42:39 2018
// NETLIST TIME: Apr  5 11:42:26 2021

`worklib GATES_3V
`view schematic

`timescale 1ns / 1ps
(* cds_ams_schematic *)

module invrv3 (out, in);
output  out;
input  in;
wire (*
integer inh_conn_prop_name = "power_vdd3";
integer inh_conn_def_value = "cds_globals.\\vdd3! "; *)
\vdd3! ;
wire (*
integer inh_conn_prop_name = "ground_gnd";
integer inh_conn_def_value = "cds_globals.\\gnd! "; *)
\gnd! ;
parameter GT_PDW=0 ;
parameter GT_PDL=3.5e-07 ;
parameter sx=4.8e-07 ;
parameter lc=2.7e-07 ;
parameter GT_PUW=0 ;
parameter GT_PUL=3e-07 ;
ne3 #(.w(GT_PDW), .l(GT_PDL), .as(sx*(GT_PDW)), .ad(sx*(GT_PDW)), .ps(2*sx+(GT_PDW)), .pd(2*sx+(GT_PDW)), .nrs(lc/(GT_PDW)), .nrd(lc/(GT_PDW)), .m((1)*(1)), .par1((1)*(1)), .xf_subext(0))
(* integer passed_mfactor = "m"; *)
 MN1 (out, in, \gnd! , \gnd! );
pe3 #(.w(GT_PUW), .l(GT_PUL), .as(sx*(GT_PUW)), .ad(sx*(GT_PUW)), .ps(2*sx+(GT_PUW)), .pd(2*sx+(GT_PUW)), .nrs(lc/(GT_PUW)), .nrd(lc/(GT_PUW)), .m((1)*(1)), .par1((1)*(1)))
(* integer passed_mfactor = "m"; *)
 MP1 (out, in, \vdd3! , \vdd3! );

endmodule
// Library - D_CELLS_HD, Cell - AND2HDX0, View - cmos_sch
// LAST TIME SAVED: Jan 23 08:10:19 2018
// NETLIST TIME: Apr  5 11:42:26 2021

`worklib D_CELLS_HD
`view cmos_sch

`timescale 1ns / 1ps
(* cds_ams_schematic *)

module AND2HDX0 (Q, A, B);
output  Q;
input  A, B;
wire (*
integer inh_conn_prop_name = "ground_gnd";
integer inh_conn_def_value = "cds_globals.\\gnd! "; *)
\gnd! ;
wire (*
integer inh_conn_prop_name = "power_vdd";
integer inh_conn_def_value = "cds_globals.\\vdd! "; *)
\vdd! ;
wire net10;
nand2 #(.sx(4.8e-07), .GT_PUW(7.2e-07), .GT_PDL(1.8e-07), .lc(2.7e-07), .GT_PUL(1.8e-07), .GT_PDW(4.2e-07)) nand2_1 (.a( A ), .b( B ), .out( net10 ));
invr #(.sx(4.8e-07), .GT_PUW(7.2e-07), .GT_PDL(1.8e-07), .lc(2.7e-07), .GT_PUL(1.8e-07), .GT_PDW(4.2e-07)) invr_1 (.out( Q ), .in( net10 ));

endmodule
// Library - D_CELLS_3V, Cell - IN_3VX2, View - cmos_sch
// LAST TIME SAVED: Feb 20 10:23:55 2018
// NETLIST TIME: Apr  5 11:42:26 2021

`worklib D_CELLS_3V
`view cmos_sch

`timescale 1ns / 1ps
(* cds_ams_schematic *)

module IN_3VX2 (Q, A);
output  Q;
input  A;
wire (*
integer inh_conn_prop_name = "power_vdd3";
integer inh_conn_def_value = "cds_globals.\\vdd3! "; *)
\vdd3! ;
wire (*
integer inh_conn_prop_name = "ground_gnd";
integer inh_conn_def_value = "cds_globals.\\gnd! "; *)
\gnd! ;
invrv3 #(.sx(4.8e-07), .GT_PUW(2.94e-06), .GT_PDL(3.5e-07), .lc(2.7e-07), .GT_PUL(3e-07), .GT_PDW(9.6e-07)) invr_1 (.in( A ), .out( Q ));

endmodule
// Library - Stimulator_TestBench, Cell - TB_ChannelSelection_imp, View - schematic
// LAST TIME SAVED: Apr  5 11:42:16 2021
// NETLIST TIME: Apr  5 11:42:26 2021

`worklib Stimulator_TestBench
`view schematic

`timescale 1ns / 1ps
(* cds_ams_schematic *)

module TB_ChannelSelection_imp ( );
wire [4:0] Mag_ST;
wire [3:0] ChSel_LS;
wire [7:0] CtrlLS;
wire [7:0] CtrlHS;
wire [3:0] ChSel_HS;
wire Ist;
wire net12;
wire vddh;
wire net13;
wire net14;
wire net15;
wire net16;
wire net17;
wire net18;
wire net19;
wire Enable_ST;
wire net08;
HalfBridge_ST I19 (.\vdd3! (cds_globals.\vdd3! ), .vddh( vddh ), .\vdde! (cds_globals.\vdde! ), .\gnd! (cds_globals.\gnd! ), .Ctrl_LS( CtrlLS[7] ), .Ctrl_HS( CtrlHS[7] ), .OUT( net12 ), .Ist( Ist ));
HalfBridge_ST I17 (.\vdd3! (cds_globals.\vdd3! ), .vddh( vddh ), .\vdde! (cds_globals.\vdde! ), .\gnd! (cds_globals.\gnd! ), .Ctrl_LS( CtrlLS[6] ), .Ctrl_HS( CtrlHS[6] ), .OUT( net13 ), .Ist( Ist ));
HalfBridge_ST I15 (.\vdd3! (cds_globals.\vdd3! ), .vddh( vddh ), .\vdde! (cds_globals.\vdde! ), .\gnd! (cds_globals.\gnd! ), .Ctrl_LS( CtrlLS[5] ), .Ctrl_HS( CtrlHS[5] ), .OUT( net14 ), .Ist( Ist ));
HalfBridge_ST I13 (.\vdd3! (cds_globals.\vdd3! ), .vddh( vddh ), .\vdde! (cds_globals.\vdde! ), .\gnd! (cds_globals.\gnd! ), .Ctrl_LS( CtrlLS[4] ), .Ctrl_HS( CtrlHS[4] ), .OUT( net15 ), .Ist( Ist ));
HalfBridge_ST I11 (.\vdd3! (cds_globals.\vdd3! ), .vddh( vddh ), .\vdde! (cds_globals.\vdde! ), .\gnd! (cds_globals.\gnd! ), .Ctrl_LS( CtrlLS[3] ), .Ctrl_HS( CtrlHS[3] ), .OUT( net16 ), .Ist( Ist ));
HalfBridge_ST I9 (.\vdd3! (cds_globals.\vdd3! ), .vddh( vddh ), .\vdde! (cds_globals.\vdde! ), .\gnd! (cds_globals.\gnd! ), .Ctrl_LS( CtrlLS[2] ), .Ctrl_HS( CtrlHS[2] ), .OUT( net17 ), .Ist( Ist ));
HalfBridge_ST I7 (.\vdd3! (cds_globals.\vdd3! ), .vddh( vddh ), .\vdde! (cds_globals.\vdde! ), .\gnd! (cds_globals.\gnd! ), .Ctrl_LS( CtrlLS[1] ), .Ctrl_HS( CtrlHS[1] ), .OUT( net18 ), .Ist( Ist ));
HalfBridge_ST I0 (.Ist( Ist ), .\vdd3! (cds_globals.\vdd3! ), .vddh( vddh ), .\vdde! (cds_globals.\vdde! ), .\gnd! (cds_globals.\gnd! ), .Ctrl_LS( CtrlLS[0] ), .Ctrl_HS( CtrlHS[0] ), .OUT( net19 ));
CurrentSource_All_ST I26 (.vss(cds_globals.\gnd! ), .Ist( Ist ), .Iext( net08 ), .vdd3(cds_globals.\vdd3! ), .vddh( vddh ), .Enable_ST( Enable_ST ), .Mag0_ST( Mag_ST[0] ), .Mag1_ST( Mag_ST[1] ), .Mag2_ST( Mag_ST[2] ), .Mag3_ST( Mag_ST[3] ), .Mag4_ST( Mag_ST[4] ));
Decoder8 I30 (.Dout( CtrlHS ), .Bin( ChSel_HS ));
Decoder8 I31 (.Dout( CtrlLS ), .Bin( ChSel_LS ));
Digital_Stimulus_V2_ST #(.Ch_Sweeping(1'b1)) I32 (.ChSel_HS( ChSel_HS ), .ChSel_LS( ChSel_LS ), .EN_ST( Enable_ST ), .MAG_ST( Mag_ST ));
vsource #(.dc(1.8), .type("dc")) V3 (cds_globals.\vdd! , cds_globals.\gnd! );
vsource #(.dc(40), .type("dc")) V2 (vddh, cds_globals.\gnd! );
vsource #(.dc(1.8), .type("dc")) V0 (cds_globals.\vdde! , cds_globals.\gnd! );
vsource #(.dc(3.3), .type("dc")) V1 (cds_globals.\vdd3! , cds_globals.\gnd! );
resistor #(.r(0)) R10 (net04, net06);
resistor #(.r(0)) R9 (net02, net04);
resistor #(.r(0)) R8 (net01, net02);
resistor #(.r(500)) R7 (net16, net01);
resistor #(.r(500)) R6 (net01, net12);
resistor #(.r(500)) R5 (net02, net13);
resistor #(.r(500)) R4 (net17, net02);
resistor #(.r(500)) R3 (net04, net14);
resistor #(.r(500)) R2 (net18, net04);
resistor #(.r(500)) R1 (net06, net15);
resistor #(.r(500)) R0 (net19, net06);
isource #(.dc(1e-05), .type("dc")) I27 (cds_globals.\vdd3! , net08);

endmodule
// Library - D_CELLS_M3V, Cell - LSHVT18U3VX1, View - cmos_sch
// LAST TIME SAVED: Jun  7 14:44:58 2018
// NETLIST TIME: Apr  5 11:42:26 2021

`worklib D_CELLS_M3V
`view cmos_sch

`timescale 1ns / 1ps
(* cds_ams_schematic *)

module LSHVT18U3VX1 (Q, A);
output  Q;
input  A;
wire (*
integer inh_conn_prop_name = "power_vdd3";
integer inh_conn_def_value = "cds_globals.\\vdd3! "; *)
\vdd3! ;
wire (*
integer inh_conn_prop_name = "ground_gnd";
integer inh_conn_def_value = "cds_globals.\\gnd! "; *)
\gnd! ;
wire (*
integer inh_conn_prop_name = "power_vdde";
integer inh_conn_def_value = "cds_globals.\\vdde! "; *)
\vdde! ;
pe3 #(.w(1.46e-06), .l(3e-07), .as(7.008e-13), .ad(7.008e-13), .ps(3.88e-06), .pd(3.88e-06), .nrs(0.184932), .nrd(0.184932), .m((1)*(1)), .par1((1)*(1)))
(* integer passed_mfactor = "m"; *)
 M6 (Q, net20, \vdd3! , \vdd3! );
pe3 #(.w(1.48e-06), .l(3e-07), .as(7.104e-13), .ad(7.104e-13), .ps(3.92e-06), .pd(3.92e-06), .nrs(0.182432), .nrd(0.182432), .m((1)*(1)), .par1((1)*(1)))
(* integer passed_mfactor = "m"; *)
 M8 (net4, A, \vdde! , \vdd3! );
pe3 #(.w(4.2e-07), .l(3e-07), .as(2.016e-13), .ad(2.016e-13), .ps(1.8e-06), .pd(1.8e-06), .nrs(0.642857), .nrd(0.642857), .m((1)*(1)), .par1((1)*(1)))
(* integer passed_mfactor = "m"; *)
 M9 (net20, A, net024, \vdd3! );
pe3 #(.w(4.2e-07), .l(3e-07), .as(2.016e-13), .ad(2.016e-13), .ps(1.8e-06), .pd(1.8e-06), .nrs(0.642857), .nrd(0.642857), .m((1)*(1)), .par1((1)*(1)))
(* integer passed_mfactor = "m"; *)
 M0 (net10, net4, net023, \vdd3! );
pe3 #(.w(4.2e-07), .l(3e-07), .as(2.016e-13), .ad(2.016e-13), .ps(1.8e-06), .pd(1.8e-06), .nrs(0.642857), .nrd(0.642857), .m((1)*(1)), .par1((1)*(1)))
(* integer passed_mfactor = "m"; *)
 M2 (net023, net20, \vdd3! , \vdd3! );
pe3 #(.w(4.2e-07), .l(3e-07), .as(2.016e-13), .ad(2.016e-13), .ps(1.8e-06), .pd(1.8e-06), .nrs(0.642857), .nrd(0.642857), .m((1)*(1)), .par1((1)*(1)))
(* integer passed_mfactor = "m"; *)
 M4 (net024, net10, \vdd3! , \vdd3! );
ne3 #(.w(1.31e-06), .l(3.5e-07), .as(6.288e-13), .ad(6.288e-13), .ps(3.58e-06), .pd(3.58e-06), .nrs(0.206107), .nrd(0.206107), .m((1)*(1)), .par1((1)*(1)), .xf_subext(0))
(* integer passed_mfactor = "m"; *)
 M3 (net20, A, \gnd! , \gnd! );
ne3 #(.w(8.9e-07), .l(3.5e-07), .as(4.272e-13), .ad(4.272e-13), .ps(2.74e-06), .pd(2.74e-06), .nrs(0.303371), .nrd(0.303371), .m((1)*(1)), .par1((1)*(1)), .xf_subext(0))
(* integer passed_mfactor = "m"; *)
 M5 (Q, net20, \gnd! , \gnd! );
ne3 #(.w(4.2e-07), .l(3.5e-07), .as(2.016e-13), .ad(2.016e-13), .ps(1.8e-06), .pd(1.8e-06), .nrs(0.642857), .nrd(0.642857), .m((1)*(1)), .par1((1)*(1)), .xf_subext(0))
(* integer passed_mfactor = "m"; *)
 M7 (net4, A, \gnd! , \gnd! );
ne3 #(.w(1.31e-06), .l(3.5e-07), .as(6.288e-13), .ad(6.288e-13), .ps(3.58e-06), .pd(3.58e-06), .nrs(0.206107), .nrd(0.206107), .m((1)*(1)), .par1((1)*(1)), .xf_subext(0))
(* integer passed_mfactor = "m"; *)
 M1 (net10, net4, \gnd! , \gnd! );

endmodule
// Library - D_CELLS_M3V, Cell - LSHVT18U3VX2, View - cmos_sch
// LAST TIME SAVED: Jun  7 14:44:51 2018
// NETLIST TIME: Apr  5 11:42:26 2021

`worklib D_CELLS_M3V
`view cmos_sch

`timescale 1ns / 1ps
(* cds_ams_schematic *)

module LSHVT18U3VX2 (Q, A);
output  Q;
input  A;
wire (*
integer inh_conn_prop_name = "power_vdd3";
integer inh_conn_def_value = "cds_globals.\\vdd3! "; *)
\vdd3! ;
wire (*
integer inh_conn_prop_name = "ground_gnd";
integer inh_conn_def_value = "cds_globals.\\gnd! "; *)
\gnd! ;
wire (*
integer inh_conn_prop_name = "power_vdde";
integer inh_conn_def_value = "cds_globals.\\vdde! "; *)
\vdde! ;
pe3 #(.w(2.82e-06), .l(3e-07), .as(1.3536e-12), .ad(1.3536e-12), .ps(6.6e-06), .pd(6.6e-06), .nrs(0.0957447), .nrd(0.0957447), .m((1)*(1)), .par1((1)*(1)))
(* integer passed_mfactor = "m"; *)
 M6 (Q, net20, \vdd3! , \vdd3! );
pe3 #(.w(1.47e-06), .l(3e-07), .as(7.056e-13), .ad(7.056e-13), .ps(3.9e-06), .pd(3.9e-06), .nrs(0.183673), .nrd(0.183673), .m((1)*(1)), .par1((1)*(1)))
(* integer passed_mfactor = "m"; *)
 M8 (net4, A, \vdde! , \vdd3! );
pe3 #(.w(4.2e-07), .l(3e-07), .as(2.016e-13), .ad(2.016e-13), .ps(1.8e-06), .pd(1.8e-06), .nrs(0.642857), .nrd(0.642857), .m((1)*(1)), .par1((1)*(1)))
(* integer passed_mfactor = "m"; *)
 M9 (net20, A, net024, \vdd3! );
pe3 #(.w(4.2e-07), .l(3e-07), .as(2.016e-13), .ad(2.016e-13), .ps(1.8e-06), .pd(1.8e-06), .nrs(0.642857), .nrd(0.642857), .m((1)*(1)), .par1((1)*(1)))
(* integer passed_mfactor = "m"; *)
 M0 (net10, net4, net023, \vdd3! );
pe3 #(.w(4.2e-07), .l(3e-07), .as(2.016e-13), .ad(2.016e-13), .ps(1.8e-06), .pd(1.8e-06), .nrs(0.642857), .nrd(0.642857), .m((1)*(1)), .par1((1)*(1)))
(* integer passed_mfactor = "m"; *)
 M2 (net023, net20, \vdd3! , \vdd3! );
pe3 #(.w(4.2e-07), .l(3e-07), .as(2.016e-13), .ad(2.016e-13), .ps(1.8e-06), .pd(1.8e-06), .nrs(0.642857), .nrd(0.642857), .m((1)*(1)), .par1((1)*(1)))
(* integer passed_mfactor = "m"; *)
 M4 (net024, net10, \vdd3! , \vdd3! );
ne3 #(.w(1.31e-06), .l(3.5e-07), .as(6.288e-13), .ad(6.288e-13), .ps(3.58e-06), .pd(3.58e-06), .nrs(0.206107), .nrd(0.206107), .m((1)*(1)), .par1((1)*(1)), .xf_subext(0))
(* integer passed_mfactor = "m"; *)
 M3 (net20, A, \gnd! , \gnd! );
ne3 #(.w(1.78e-06), .l(3.5e-07), .as(8.544e-13), .ad(8.544e-13), .ps(4.52e-06), .pd(4.52e-06), .nrs(0.151685), .nrd(0.151685), .m((1)*(1)), .par1((1)*(1)), .xf_subext(0))
(* integer passed_mfactor = "m"; *)
 M5 (Q, net20, \gnd! , \gnd! );
ne3 #(.w(4.2e-07), .l(3.5e-07), .as(2.016e-13), .ad(2.016e-13), .ps(1.8e-06), .pd(1.8e-06), .nrs(0.642857), .nrd(0.642857), .m((1)*(1)), .par1((1)*(1)), .xf_subext(0))
(* integer passed_mfactor = "m"; *)
 M7 (net4, A, \gnd! , \gnd! );
ne3 #(.w(1.31e-06), .l(3.5e-07), .as(6.288e-13), .ad(6.288e-13), .ps(3.58e-06), .pd(3.58e-06), .nrs(0.206107), .nrd(0.206107), .m((1)*(1)), .par1((1)*(1)), .xf_subext(0))
(* integer passed_mfactor = "m"; *)
 M1 (net10, net4, \gnd! , \gnd! );

endmodule
// Library - GATES_HD, Cell - nand2, View - schematic
// LAST TIME SAVED: Jan 18 15:00:04 2018
// NETLIST TIME: Apr  5 11:42:26 2021

`worklib GATES_HD
`view schematic

`timescale 1ns / 1ps
(* cds_ams_schematic *)

module nand2 (out, a, b);
output  out;
input  a, b;
wire (*
integer inh_conn_prop_name = "ground_gnd";
integer inh_conn_def_value = "cds_globals.\\gnd! "; *)
\gnd! ;
wire (*
integer inh_conn_prop_name = "power_vdd";
integer inh_conn_def_value = "cds_globals.\\vdd! "; *)
\vdd! ;
parameter GT_PDW=0 ;
parameter GT_PDL=1.8e-07 ;
parameter sx=4.8e-07 ;
parameter lc=2.7e-07 ;
parameter GT_PUW=0 ;
parameter GT_PUL=1.8e-07 ;
ne #(.w(GT_PDW), .l(GT_PDL), .as(sx*(GT_PDW)), .ad(sx*(GT_PDW)), .ps(2*(sx+(GT_PDW))), .pd(2*(sx+(GT_PDW))), .nrs(lc/(GT_PDW)), .nrd(lc/(GT_PDW)), .m((1)*(1)), .par1((1)*(1)), .xf_subext(0))
(* integer passed_mfactor = "m"; *)
 MN1 (out, a, net11, \gnd! );
ne #(.w(GT_PDW), .l(GT_PDL), .as(sx*(GT_PDW)), .ad(sx*(GT_PDW)), .ps(2*(sx+(GT_PDW))), .pd(2*(sx+(GT_PDW))), .nrs(lc/(GT_PDW)), .nrd(lc/(GT_PDW)), .m((1)*(1)), .par1((1)*(1)), .xf_subext(0))
(* integer passed_mfactor = "m"; *)
 MN2 (net11, b, \gnd! , \gnd! );
pe #(.w(GT_PUW), .l(GT_PUL), .as(sx*(GT_PUW)), .ad(sx*(GT_PUW)), .ps(2*(sx+(GT_PUW))), .pd(2*(sx+(GT_PUW))), .nrs(lc/(GT_PUW)), .nrd(lc/(GT_PUW)), .m((1)*(1)), .par1((1)*(1)))
(* integer passed_mfactor = "m"; *)
 MP1 (out, a, \vdd! , \vdd! );
pe #(.w(GT_PUW), .l(GT_PUL), .as(sx*(GT_PUW)), .ad(sx*(GT_PUW)), .ps(2*(sx+(GT_PUW))), .pd(2*(sx+(GT_PUW))), .nrs(lc/(GT_PUW)), .nrd(lc/(GT_PUW)), .m((1)*(1)), .par1((1)*(1)))
(* integer passed_mfactor = "m"; *)
 MP2 (out, b, \vdd! , \vdd! );

endmodule
// Library - GATES_HD, Cell - invr, View - schematic
// LAST TIME SAVED: Jan 18 15:00:13 2018
// NETLIST TIME: Apr  5 11:42:26 2021

`worklib GATES_HD
`view schematic

`timescale 1ns / 1ps
(* cds_ams_schematic *)

module invr (out, in);
output  out;
input  in;
wire (*
integer inh_conn_prop_name = "ground_gnd";
integer inh_conn_def_value = "cds_globals.\\gnd! "; *)
\gnd! ;
wire (*
integer inh_conn_prop_name = "power_vdd";
integer inh_conn_def_value = "cds_globals.\\vdd! "; *)
\vdd! ;
parameter GT_PDW=0 ;
parameter GT_PDL=1.8e-07 ;
parameter sx=4.8e-07 ;
parameter lc=2.7e-07 ;
parameter GT_PUW=0 ;
parameter GT_PUL=1.8e-07 ;
ne #(.w(GT_PDW), .l(GT_PDL), .as(sx*(GT_PDW)), .ad(sx*(GT_PDW)), .ps(2*(sx+(GT_PDW))), .pd(2*(sx+(GT_PDW))), .nrs(lc/(GT_PDW)), .nrd(lc/(GT_PDW)), .m((1)*(1)), .par1((1)*(1)), .xf_subext(0))
(* integer passed_mfactor = "m"; *)
 ne (out, in, \gnd! , \gnd! );
pe #(.w(GT_PUW), .l(GT_PUL), .as(sx*(GT_PUW)), .ad(sx*(GT_PUW)), .ps(2*(sx+(GT_PUW))), .pd(2*(sx+(GT_PUW))), .nrs(lc/(GT_PUW)), .nrd(lc/(GT_PUW)), .m((1)*(1)), .par1((1)*(1)))
(* integer passed_mfactor = "m"; *)
 pe (out, in, \vdd! , \vdd! );

endmodule
`noworklib
`noview
