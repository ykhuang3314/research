// AMS netlist generated by the AMS Unified netlister
// IC subversion:  IC6.1.8-64b.500.7
// Xcelium version: 18.03-s018
// Copyright(C) 2005-2009, Cadence Design Systems, Inc
// User: ykhuang Pid: 10648
// Design library name: EMG_TestBench
// Design cell name: TB_Digital_Stimulus_EMG_NMES
// Design view name: config
// Solver: Spectre

`include "disciplines.vams"
`include "userDisciplines.vams"
// HDL file - Stimulator_Model, Digital_Stimulus_ST_V2, functional.
// HDL file - EMG_Model, Digital_Stimuli_EMG_V2, functional.
// HDL file - EMG_Model, Digital_Stimuli_EMG_NMES_V2, functional.
// Library - EMG_TestBench, Cell - TB_Digital_Stimulus_EMG_NMES, View - schematic
// LAST TIME SAVED: Feb 15 14:48:32 2021
// NETLIST TIME: Feb 15 22:34:37 2021

`worklib EMG_TestBench
`view schematic

`timescale 1ns / 1ps
(* cds_ams_schematic *)

module TB_Digital_Stimulus_EMG_NMES ( );
wire [4:0] MAG_ST;
wire [1:0] CH_SEL_ST;
wire [3:0] CH_SEL_EMG;
wire net4;
wire net1;
wire net3;
wire START_EMG;
wire MUX_CLK_EMG;
wire EN_ST;
wire EN_ADC_EMG;
wire DIS_ST;
wire CAT_ST;
wire ANO_ST;
wire ADC_CLK_EMG;
Digital_Stimuli_EMG_NMES_V2 #(.num_of_ch_EMG(8)) I2 (.ADC_CLK_EMG( ADC_CLK_EMG ), .ANO_ST( ANO_ST ), .CAT_ST( CAT_ST ), .CH_SEL_EMG( CH_SEL_EMG ), .CH_SEL_ST( CH_SEL_ST ), .DIS_ST( DIS_ST ), .EN_ADC_EMG( EN_ADC_EMG ), .EN_ST( EN_ST ), .MAG_ST( MAG_ST ), .MUX_CLK_EMG( MUX_CLK_EMG ), .START_EMG( START_EMG ), .CH_SWEEP_ST( net3 ), .ENABLE( net1 ), .RAMP_ST( net4 ), .RESET(cds_globals.\gnd! ));
vsource #(.type("pwl"), .wave({"0", "0", "1e-05", "1.8"})) V0 (net1, cds_globals.\gnd! );
vsource #(.dc(0), .type("dc")) V1 (net4, cds_globals.\gnd! );
vsource #(.dc(1.8), .type("dc")) V5 (net3, cds_globals.\gnd! );

endmodule
`noworklib
`noview
