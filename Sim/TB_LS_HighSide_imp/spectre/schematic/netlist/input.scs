// Design: Stimulator_TestBench/TB_LS_HighSide_imp
simulator lang=spectre
global 0 vdd3! vdde!
include "/pkg/xfab/XKIT/xh018/cadence/v8_0/spectre/v8_0_1/lpmos/config.scs" section=default
include "/pkg/xfab/XKIT/xh018/cadence/v8_0/spectre/v8_0_1/lpmos/param.scs" section=3s
include "/pkg/xfab/XKIT/xh018/cadence/v8_0/spectre/v8_0_1/lpmos/bip.scs" section=tm
include "/pkg/xfab/XKIT/xh018/cadence/v8_0/spectre/v8_0_1/lpmos/cap.scs" section=tm
include "/pkg/xfab/XKIT/xh018/cadence/v8_0/spectre/v8_0_1/lpmos/dio.scs" section=tm
include "/pkg/xfab/XKIT/xh018/cadence/v8_0/spectre/v8_0_1/lpmos/mos.scs" section=tm
include "/pkg/xfab/XKIT/xh018/cadence/v8_0/spectre/v8_0_1/lpmos/photo.scs" section=tm
include "/pkg/xfab/XKIT/xh018/cadence/v8_0/spectre/v8_0_1/lpmos/res.scs" section=tm

// Stimulator_IMP/ResistiveDivider/schematic
subckt ResistiveDivider V1 V2 VOUT
    R37 (net09 V2) rpp1k1 l=23.0u w=2u m=1 par1=(1)
    R36 (net010 net09) rpp1k1 l=23.0u w=2u m=1 par1=(1)
    R35 (net011 net010) rpp1k1 l=23.0u w=2u m=1 par1=(1)
    R34 (net012 net011) rpp1k1 l=23.0u w=2u m=1 par1=(1)
    R33 (net013 net012) rpp1k1 l=23.0u w=2u m=1 par1=(1)
    R32 (net014 net013) rpp1k1 l=23.0u w=2u m=1 par1=(1)
    R31 (net015 net014) rpp1k1 l=23.0u w=2u m=1 par1=(1)
    R30 (net016 net015) rpp1k1 l=23.0u w=2u m=1 par1=(1)
    R29 (net017 net016) rpp1k1 l=23.0u w=2u m=1 par1=(1)
    R28 (net018 net017) rpp1k1 l=23.0u w=2u m=1 par1=(1)
    R27 (net019 net018) rpp1k1 l=23.0u w=2u m=1 par1=(1)
    R26 (VOUT net019) rpp1k1 l=23.0u w=2u m=1 par1=(1)
    R25 (net020 VOUT) rpp1k1 l=23.0u w=2u m=1 par1=(1)
    R24 (net021 net020) rpp1k1 l=23.0u w=2u m=1 par1=(1)
    R23 (net022 net021) rpp1k1 l=23.0u w=2u m=1 par1=(1)
    R22 (net023 net022) rpp1k1 l=23.0u w=2u m=1 par1=(1)
    R21 (net024 net023) rpp1k1 l=23.0u w=2u m=1 par1=(1)
    R20 (net025 net024) rpp1k1 l=23.0u w=2u m=1 par1=(1)
    R19 (net026 net025) rpp1k1 l=23.0u w=2u m=1 par1=(1)
    R18 (net027 net026) rpp1k1 l=23.0u w=2u m=1 par1=(1)
    R17 (net028 net027) rpp1k1 l=23.0u w=2u m=1 par1=(1)
    R16 (net029 net028) rpp1k1 l=23.0u w=2u m=1 par1=(1)
    R15 (net030 net029) rpp1k1 l=23.0u w=2u m=1 par1=(1)
    R14 (net031 net030) rpp1k1 l=23.0u w=2u m=1 par1=(1)
    R13 (net032 net031) rpp1k1 l=23.0u w=2u m=1 par1=(1)
    R12 (net033 net032) rpp1k1 l=23.0u w=2u m=1 par1=(1)
    R11 (net034 net033) rpp1k1 l=23.0u w=2u m=1 par1=(1)
    R10 (net035 net034) rpp1k1 l=23.0u w=2u m=1 par1=(1)
    R9 (net036 net035) rpp1k1 l=23.0u w=2u m=1 par1=(1)
    R8 (net037 net036) rpp1k1 l=23.0u w=2u m=1 par1=(1)
    R7 (net038 net037) rpp1k1 l=23.0u w=2u m=1 par1=(1)
    R6 (V1 net038) rpp1k1 l=23.0u w=2u m=1 par1=(1)
    R5 (net08 net08) rpp1k1 l=23.0u w=2u m=1 par1=(1)
    R4 (net07 net07) rpp1k1 l=23.0u w=2u m=1 par1=(1)
    R3 (net5 net5) rpp1k1 l=23.0u w=2u m=1 par1=(1)
    R2 (net6 net6) rpp1k1 l=23.0u w=2u m=1 par1=(1)
ends ResistiveDivider

// D_CELLS_M3V/LSHVT18U3VX1/cmos_sch
subckt LSHVT18U3VX1 A Q inh_ground_gnd inh_power_vdd3 inh_power_vdde
    M6 (Q net20 inh_power_vdd3 inh_power_vdd3) pe3 w=1.46u l=300n m=(1)*(1)
    M8 (net4 A inh_power_vdde inh_power_vdd3) pe3 w=1.48u l=300n m=(1)*(1)
    M9 (net20 A net024 inh_power_vdd3) pe3 w=420.0n l=300n m=(1)*(1)
    M0 (net10 net4 net023 inh_power_vdd3) pe3 w=420.0n l=300n m=(1)*(1)
    M2 (net023 net20 inh_power_vdd3 inh_power_vdd3) pe3 w=420.0n l=300n m=(1)*(1)
    M4 (net024 net10 inh_power_vdd3 inh_power_vdd3) pe3 w=420.0n l=300n m=(1)*(1)
    M3 (net20 A inh_ground_gnd inh_ground_gnd) ne3 w=1.31u l=350.0n m=(1)*(1)
    M5 (Q net20 inh_ground_gnd inh_ground_gnd) ne3 w=890.0n l=350.0n m=(1)*(1)
    M7 (net4 A inh_ground_gnd inh_ground_gnd) ne3 w=420.0n l=350.0n m=(1)*(1)
    M1 (net10 net4 inh_ground_gnd inh_ground_gnd) ne3 w=1.31u l=350.0n m=(1)*(1)
ends LSHVT18U3VX1

// Stimulator_TestBench/TB_LS_HighSide_imp/schematic
M13 (net015 in_3v 0 0) nedia_bjt w=10u l=1.25u m=(1)*(1) par1=((1)*(1)) extlay=0 xf_subext=0
V0 (in 0) vsource dc=1.8 type=pulse val0=0 val1=1.8 period=100u delay=50u rise=1p fall=1p width=50u
C0 (vout 0) capacitor c=1p
V3 (vddH 0) vsource dc=40 type=dc
V2 (vdde! 0) vsource dc=1.8 type=dc
V1 (vdd3! 0) vsource dc=3.3 type=dc
I19 (vddH net015 vout) ResistiveDivider
I10 (in in_3v 0 vdd3! vdde!) LSHVT18U3VX1
simulatorOptions options reltol=100e-6 temp=27 homotopy=all limit=delta compatible=spice2
tran tran stop=500u errpreset=conservative
