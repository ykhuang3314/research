// Design: Stimulator_TestBench/TB_HBridge_DC
simulator lang=spectre
global 0 vdd3! vdde!
parameters Iref=100u
include "/pkg/xfab/XKIT/xh018/cadence/v8_0/spectre/v8_0_1/lpmos/config.scs" section=default
include "/pkg/xfab/XKIT/xh018/cadence/v8_0/spectre/v8_0_1/lpmos/param.scs" section=3s
include "/pkg/xfab/XKIT/xh018/cadence/v8_0/spectre/v8_0_1/lpmos/bip.scs" section=tm
include "/pkg/xfab/XKIT/xh018/cadence/v8_0/spectre/v8_0_1/lpmos/cap.scs" section=tm
include "/pkg/xfab/XKIT/xh018/cadence/v8_0/spectre/v8_0_1/lpmos/dio.scs" section=tm
include "/pkg/xfab/XKIT/xh018/cadence/v8_0/spectre/v8_0_1/lpmos/mos.scs" section=tm
include "/pkg/xfab/XKIT/xh018/cadence/v8_0/spectre/v8_0_1/lpmos/photo.scs" section=tm
include "/pkg/xfab/XKIT/xh018/cadence/v8_0/spectre/v8_0_1/lpmos/res.scs" section=tm

// D_CELLS_M3V/LSHVT18U3VX1/cmos_sch
subckt LSHVT18U3VX1 A Q inh_ground_gnd inh_power_vdd3 inh_power_vdde
    M6 (Q net20 inh_power_vdd3 inh_power_vdd3) pe3 w=1.46u l=300n m=(1)*(1)
    M8 (net4 A inh_power_vdde inh_power_vdd3) pe3 w=1.48u l=300n m=(1)*(1)
    M9 (net20 A net024 inh_power_vdd3) pe3 w=420.0n l=300n m=(1)*(1)
    M0 (net10 net4 net023 inh_power_vdd3) pe3 w=420.0n l=300n m=(1)*(1)
    M2 (net023 net20 inh_power_vdd3 inh_power_vdd3) pe3 w=420.0n l=300n m=(1)*(1)
    M4 (net024 net10 inh_power_vdd3 inh_power_vdd3) pe3 w=420.0n l=300n m=(1)*(1)
    M3 (net20 A inh_ground_gnd inh_ground_gnd) ne3 w=1.31u l=350.0n m=(1)*(1)
    M5 (Q net20 inh_ground_gnd inh_ground_gnd) ne3 w=890.0n l=350.0n m=(1)*(1)
    M7 (net4 A inh_ground_gnd inh_ground_gnd) ne3 w=420.0n l=350.0n m=(1)*(1)
    M1 (net10 net4 inh_ground_gnd inh_ground_gnd) ne3 w=1.31u l=350.0n m=(1)*(1)
ends LSHVT18U3VX1

// Stimulator_IMP/LS_LowSide_V2_ST/schematic
subckt LS_LowSide_V2_ST 0 in out vdd3! vdde! vddh inh_ground_gnd inh_power_vdd3 inh_power_vdde
    M0 (net12 in_3V 0 0) nedia_bjt w=30u l=1.25u m=(1)*(1) par1=((1)*(1)) extlay=0 xf_subext=0
    R2 (net9 net12) rpp1k1 l=507.595u w=2u m=1 par1=(1)
    R0 (out 0) rpp1k1 l=304.47u w=2u m=1 par1=(1)
    R1 (vddh net9) rpp1k1 l=304.47u w=2u m=1 par1=(1)
    R3 (net11 out) rpp1k1 l=507.595u w=2u m=1 par1=(1)
    M1 (net11 net9 vddh 0) ped_bjt w=30u l=940.0n m=(1)*(1) par1=((1)*(1)) extlay=0 xf_subext=0
    I0 (in in_3V inh_ground_gnd inh_power_vdd3 inh_power_vdde) LSHVT18U3VX1
ends LS_LowSide_V2_ST

// Stimulator_IMP/LS_HighSide_V3_ST/schematic
subckt LS_HighSide_V3_ST 0 in out vdd3! vdde! vddh inh_ground_gnd inh_power_vdd3 inh_power_vdde
    M13 (net10 inn3v 0 0) nedia_bjt w=10u l=1.25u m=(1)*(5) par1=((1)*(5)) extlay=0 xf_subext=0
    R0 (vddh out) rpp1k1 l=304.47u w=2u m=1 par1=(1)
    R1 (out net10) rpp1k1 l=507.595u w=2u m=1 par1=(1)
    I10 (in inn3v inh_ground_gnd inh_power_vdd3 inh_power_vdde) LSHVT18U3VX1
ends LS_HighSide_V3_ST

// Stimulator_TestBench/TB_HBridge_DC/schematic
M25 (net022 net022 VB vss) nedia_bjt w=60u l=1.25u m=(1)*(1) par1=((1)*(1)) extlay=0 xf_subext=0
M24 (net055 VB net046 vss) nedia_bjt w=60u l=1.25u m=(1)*(1) par1=((1)*(1)) extlay=0 xf_subext=0
M23 (net6 VB net054 vss) nedia_bjt w=60u l=1.25u m=(10)*(1) par1=((10)*(1)) extlay=0 xf_subext=0
M22 (VB net022 net080 vss) nedia_bjt w=20u l=1.25u m=(1)*(1) par1=((1)*(1)) extlay=0 xf_subext=0
M21 (net080 net080 0 vss) nedia_bjt w=60u l=1.25u m=(1)*(1) par1=((1)*(1)) extlay=0 xf_subext=0
M20 (net046 net055 0 vss) nedia_bjt w=60u l=1.25u m=(1)*(1) par1=((1)*(1)) extlay=0 xf_subext=0
M19 (net054 net055 0 vss) nedia_bjt w=60u l=1.25u m=(10)*(1) par1=((10)*(1)) extlay=0 xf_subext=0
M26 (net017 net017 net055 vss) nedia_bjt w=15.0u l=1.25u m=(1)*(1) par1=((1)*(1)) extlay=0 xf_subext=0
M6 (net021 net019 0 0) nedia_bjt w=30u l=1.25u m=(1)*(1) par1=((1)*(1)) extlay=0 xf_subext=0
M13 (net9 net064 0 0) nedia_bjt w=30u l=1.25u m=(1)*(1) par1=((1)*(1)) extlay=0 xf_subext=0
M3 (net7 net010 net6 0) nedia_bjt w=100.0000u l=1.25u m=(1)*(6) par1=((1)*(6)) extlay=0 xf_subext=0
M1 (net5 Ctrl_LS net6 0) nedia_bjt w=100.0000u l=1.25u m=(1)*(6) par1=((1)*(6)) extlay=0 xf_subext=0
M4 (net016 net018 vddh 0) ped_bjt w=30u l=940.0n m=(1)*(1) par1=((1)*(1)) extlay=0 xf_subext=0
M2 (net7 Ctrl_HS vddh 0) ped_bjt w=100.0000u l=940.0n m=(1)*(6) par1=((1)*(6)) extlay=0 xf_subext=0
M0 (net5 net012 vddh 0) ped_bjt w=100.0000u l=940.0n m=(1)*(6) par1=((1)*(6)) extlay=0 xf_subext=0
R0 (net5 net7) resistor r=1K
I26 (vddh net022) isource dc=Iref type=dc
I25 (vddh net017) isource dc=Iref type=dc
V2 (vdd3! 0) vsource dc=3.3 type=dc
V1 (vdde! 0) vsource dc=1.8 type=dc
V0 (vddh 0) vsource dc=40 type=dc
I29 (0 CAT Ctrl_LS vdd3! vdde! vddh 0 vdd3! vdde!) LS_LowSide_V2_ST
I28 (0 CAT Ctrl_HS vdd3! vdde! vddh 0 vdd3! vdde!) LS_HighSide_V3_ST
I10 (ANO net064 0 vdd3! vdde!) LSHVT18U3VX1
I11 (ANO net019 0 vdd3! vdde!) LSHVT18U3VX1
R18 (net018 net021) rpp1k1 l=507.595u w=2u m=1 par1=(1)
R17 (vddh net018) rpp1k1 l=304.47u w=2u m=1 par1=(1)
R16 (net016 net010) rpp1k1 l=507.595u w=2u m=1 par1=(1)
R9 (net010 0) rpp1k1 l=304.47u w=2u m=1 par1=(1)
R8 (net012 net9) rpp1k1 l=507.595u w=2u m=1 par1=(1)
R1 (vddh net012) rpp1k1 l=304.47u w=2u m=1 par1=(1)
V6 (CAT 0) vsource dc=0 type=pulse val0=0 val1=1.8 period=500u delay=120u rise=1p fall=1p width=100u
V3 (ANO 0) vsource dc=1.8 type=pulse val0=0 val1=1.8 period=500u delay=10u rise=1p fall=1p width=100u
simulatorOptions options reltol=100e-6 temp=27 homotopy=all limit=delta compatible=spice2
tran tran stop=5m errpreset=conservative
save R0:1
