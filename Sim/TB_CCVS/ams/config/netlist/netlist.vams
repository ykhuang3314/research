// AMS netlist generated by the AMS Unified netlister
// IC subversion:  IC6.1.8-64b.500.7
// Xcelium version: 18.03-s018
// Copyright(C) 2005-2009, Cadence Design Systems, Inc
// User: ykhuang Pid: 5922
// Design library name: VerilogAMS_Practice
// Design cell name: TB_CCVS
// Design view name: config
// Solver: Spectre

`include "disciplines.vams"
`include "userDisciplines.vams"
// HDL file - VerilogAMS_Practice, CCVS, verilogams.
// Library - VerilogAMS_Practice, Cell - TB_CCVS, View - schematic
// LAST TIME SAVED: Jan  9 22:51:04 2021
// NETLIST TIME: Jan  9 22:51:13 2021

`worklib VerilogAMS_Practice
`view schematic

`timescale 1ns / 1ps
(* cds_ams_schematic *)

module TB_CCVS ( );
wire net2;
wire Vout;
CCVS I1 (.nout(cds_globals.\gnd! ), .pout( Vout ), .nin(cds_globals.\gnd! ), .pin( net2 ));
isource #(.type("sine"), .ampl(0.0001), .freq(50000)) I4 (cds_globals.\gnd! , net2);

endmodule
`noworklib
`noview
