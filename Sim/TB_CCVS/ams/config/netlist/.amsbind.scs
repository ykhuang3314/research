// -----------------------------------------------------------------------------
// (c) Copyright 2010 Cadence Design Systems, Inc. All rights reserved worldwide.
// -----------------------------------------------------------------------------

// Binding AMSD Control Block for config VerilogAMS_Practice.TB_CCVS:config
// Created On: Jan  9 22:51:15 2021
// NOTE      : DO NOT change this system generated file.

amsd {
	config designtop="VerilogAMS_Practice.TB_CCVS:schematic"

	config cell="isource" view="analogtext"
	config cell="CCVS" lib="VerilogAMS_Practice" view="verilogams"

 }
