// AMS netlist generated by the AMS Unified netlister
// IC subversion:  IC6.1.8-64b.500.7
// Xcelium version: 18.03-s018
// Copyright(C) 2005-2009, Cadence Design Systems, Inc
// User: ykhuang Pid: 10648
// Design library name: EMG_TestBench
// Design cell name: TB_Digital_Stimulus_V2
// Design view name: config
// Solver: Spectre

`include "disciplines.vams"
`include "userDisciplines.vams"
// HDL file - EMG_Model, Digital_Stimuli_EMG_V2, functional.
// Library - EMG_TestBench, Cell - TB_Digital_Stimulus_V2, View - schematic
// LAST TIME SAVED: Feb 15 15:07:47 2021
// NETLIST TIME: Feb 15 15:07:56 2021

`worklib EMG_TestBench
`view schematic

`timescale 1ns / 1ps
(* cds_ams_schematic *)

module TB_Digital_Stimulus_V2 ( );
wire [3:0] CH_SEL_EMG;
wire net1;
wire START_EMG;
wire MUX_CLK_EMG;
wire EN_ADC_EMG;
wire CLK_EMG;
Digital_Stimuli_EMG_V2 #(.num_of_channel(8)) I0 (.CH_SEL_EMG( CH_SEL_EMG ), .CLK_EMG( CLK_EMG ), .EN_ADC_EMG( EN_ADC_EMG ), .MUX_CLK_EMG( MUX_CLK_EMG ), .START_EMG( START_EMG ), .Enable( net1 ), .RESET(cds_globals.\gnd! ));
vsource #(.type("pwl"), .wave({"0", "0", "1e-05", "1.8"})) V0 (net1, cds_globals.\gnd! );

endmodule
`noworklib
`noview
