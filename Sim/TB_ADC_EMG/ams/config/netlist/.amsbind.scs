// -----------------------------------------------------------------------------
// (c) Copyright 2010 Cadence Design Systems, Inc. All rights reserved worldwide.
// -----------------------------------------------------------------------------

// Binding AMSD Control Block for config EMG_TestBench.TB_ADC_EMG:config
// Created On: Feb 14 23:54:56 2021
// NOTE      : DO NOT change this system generated file.

amsd {
	config designtop="EMG_TestBench.TB_ADC_EMG:schematic"

	config cell="DAC_EMG" lib="EMG_Model" view="verilogams"
	config cell="ANA_MUX_EMG" lib="EMG_Model" view="verilogams"
	config cell="isource" view="analogtext"
	config cell="vsource" view="analogtext"
	config cell="Digital_Stimuli_EMG_V2" lib="EMG_Model" view="functional"
	config cell="ADC_EMG" lib="EMG_Model" view="verilogams"

 }
