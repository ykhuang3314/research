// Design: Stimulator_TestBench/TB_HighSide_LS_SW_DCop
simulator lang=spectre
global 0 vdd3! vdde!
parameters Ist=30m Ibias=100u
include "/pkg/xfab/XKIT/xh018/cadence/v8_0/spectre/v8_0_1/lpmos/config.scs" section=default
include "/pkg/xfab/XKIT/xh018/cadence/v8_0/spectre/v8_0_1/lpmos/param.scs" section=3s
include "/pkg/xfab/XKIT/xh018/cadence/v8_0/spectre/v8_0_1/lpmos/bip.scs" section=tm
include "/pkg/xfab/XKIT/xh018/cadence/v8_0/spectre/v8_0_1/lpmos/cap.scs" section=tm
include "/pkg/xfab/XKIT/xh018/cadence/v8_0/spectre/v8_0_1/lpmos/dio.scs" section=tm
include "/pkg/xfab/XKIT/xh018/cadence/v8_0/spectre/v8_0_1/lpmos/mos.scs" section=tm
include "/pkg/xfab/XKIT/xh018/cadence/v8_0/spectre/v8_0_1/lpmos/photo.scs" section=tm
include "/pkg/xfab/XKIT/xh018/cadence/v8_0/spectre/v8_0_1/lpmos/res.scs" section=tm

// Stimulator_TestBench/TB_HighSide_LS_SW_DCop/schematic
R1 (vddh net12) resistor r=100k
R4 (net12 net10) resistor r=300k
R9 (vddh net8) resistor r=100k
R8 (net8 net14) resistor r=300k
M2 (net10 vdd3! net11 0) nedia_bjt w=10u l=1.25u m=(1)*(3) par1=((1)*(3)) extlay=0 xf_subext=0
M13 (net14 vdd3! 0 0) nedia_bjt w=10u l=1.25u m=(1)*(5) par1=((1)*(5)) extlay=0 xf_subext=0
M4 (net011 net12 vddh 0) ped_bjt w=40u l=940.0n m=(1)*(20) par1=((1)*(20)) extlay=0 xf_subext=0
M3 (net13 net8 vddh 0) ped_bjt w=40u l=940.0n m=(1)*(20) par1=((1)*(20)) extlay=0 xf_subext=0
V3 (vddh 0) vsource dc=40 type=dc
V2 (vdde! 0) vsource dc=1.8 type=dc
V1 (vdd3! 0) vsource dc=3.3 type=dc
M0 (net11 bias 0 0) ne3 w=2u l=350.0n m=(1)*(10)
M1 (bias bias 0 0) ne3 w=2u l=350.0n m=(1)*(1)
I3 (net011 0) isource dc=Ist type=dc
I2 (net13 0) isource dc=Ist type=dc
I0 (vdde! bias) isource dc=Ibias type=dc
simulatorOptions options reltol=100e-6 temp=27 homotopy=all limit=delta compatible=spice2
dcOp dc
