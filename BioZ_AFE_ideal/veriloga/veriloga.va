// VerilogA for BioZ-EMG_Model, BioZ_AFE, veriloga

`include "constants.vams"
`include "disciplines.vams"

module BioZ_AFE_ideal(pin, nin, I, Q, I_DC, Q_DC, re, im, mag, pha);
	parameter real HPF_fc = 1 from (0:1k];
	parameter real IA_gain = 10 from [1:50];
	parameter real IA_BW = 1k from [1k:1M];
	parameter real PGA_gain = 1 from [1:25];
	parameter real PGA_BW = 50 from (0:1k);
	parameter real LPF_fc = 10 from (0:50];
	parameter real I_stim = 10u from [1u:1m];
	real HPF_wp[0:1] = {-`M_TWO_PI*HPF_fc,0};
	real LPF_wp[0:1] = {-`M_TWO_PI*LPF_fc,0};
	input pin, nin;
	output I_DC, Q_DC, re, im, mag, pha;
	input I, Q;
	voltage pin, nin, I, Q, I_DC, Q_DC, re, im, mag, pha;
	voltage HPF_out, IA_out, I_out, Q_out, PGA_I_out, PGA_Q_out;
		analog begin
			V(HPF_out) <+ laplace_np(V(pin)-V(nin),'{0,1/(`M_TWO_PI*HPF_fc)},'{-`M_TWO_PI*HPF_fc,0}); // High Pass Filter
			V(IA_out) <+ V(HPF_out)*IA_gain; // Instrumentation Amplifier Gain
			V(I_out) <+ V(IA_out)*V(I); //In-phase Mixing
			V(Q_out) <+ V(IA_out)*V(Q); //Quadrature Mixing
			V(PGA_I_out) <+ V(I_out)*PGA_gain; //PGA
			V(PGA_Q_out) <+ V(Q_out)*PGA_gain; //PGA
			V(I_DC) <+ laplace_np(V(PGA_I_out),'{1},'{-`M_TWO_PI*LPF_fc,0});
			V(Q_DC) <+ laplace_np(V(PGA_Q_out),'{1},'{-`M_TWO_PI*LPF_fc,0});
			V(re) <+ -2.0 * (V(I_DC) / (I_stim*IA_gain*PGA_gain));
			V(im) <+ 2.0 * (V(Q_DC) / (I_stim*IA_gain*PGA_gain));
			V(mag) <+ sqrt(pow(V(re),2)+pow(V(im),2));
			V(pha) <+ -atan(V(im)/V(re))*(180.0/`M_PI);
		end
endmodule
