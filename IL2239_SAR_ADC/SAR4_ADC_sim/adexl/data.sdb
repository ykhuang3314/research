ADE simulation setup
Run mode: Single Run, Sweeps and Corners
Tests:
  IL2239_SAR_ADC:SAR4_ADC_sim:1: IL2239_SAR_ADC/SAR4_ADC_sim/config, simulator ams
    Outputs: /I1/c4; /I1/c1; /I1/c2; /I1/c8; c1; c2; c4; c8; /out0; /out1; /out2; /out3
Global variables:
  fin = 3.5M/8
  Roff = 500M
  Ron = 140
  Cap = 25f
  Cchannel = 0
  dCap = 0
  fclk = 24M
  Vcm = 200m
  VDD = 1.8
  Vin = 180m
  Vref = 400m
