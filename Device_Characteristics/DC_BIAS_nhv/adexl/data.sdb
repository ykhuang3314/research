ADE simulation setup
Run mode: Single Run, Sweeps and Corners
Tests:
  Device_Characteristics:DC_BIAS_nhv:1: Device_Characteristics/DC_BIAS_nhv/schematic, simulator spectre
Global variables:
  W = 100u
  VGS = {From/To}Auto:0:10:18{From/To}
  VDS = 20
