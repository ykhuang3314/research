ADE simulation setup
Run mode: Single Run, Sweeps and Corners
Tests:
  EMG_NMES_TestBench:Sim_StimulusArtifact:1: EMG_NMES_TestBench/Sim_StimulusArtifact/config, simulator ams
Global variables:
  b00 = 2'b00 (off)
  b01001 = 5'b01001 (off)
