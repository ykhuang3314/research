//Verilog-AMS HDL for "BioZ_EMG_Model", "BioZ_PLL_TOP_stim" "verilogams"

`include "constants.vams"
`include "disciplines.vams"

module BioZ_PLL_TOP_stim ( Fin,FSel,Resetn);

output Fin;
output [3:0] FSel;
output Resetn;

//parameter cycle = 1428; // 700 kHz
parameter cycle = 2000; // 500 kHz

parameter [3:0] freq_selection = 4'b0000;

reg Fin;
reg Resetn;
reg [3:0] FSel;

initial begin
	Fin = 0;
	Resetn = 1;
	FSel = freq_selection;

	#200 Resetn = 0;
	#400 Resetn = 1;
end

always #(cycle/2) Fin = ~Fin;

endmodule
