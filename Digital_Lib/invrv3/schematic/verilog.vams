// Verilog-AMS netlist generated by the AMS netlister, version  IC6.1.7-64b.500.9 .
// Cadence Design Systems, Inc.

`include "disciplines.vams"

(* cds_ams_schematic *)
module invrv3 ( in,out,.gnd(\gnd! ),.vdd3(
\vdd3! ) );

input   in;
output   out;
inout  (*
integer inh_conn_prop_name
 = "ground_gnd";
integer inh_conn_def_value = "cds_globals.\\gnd! ";

 *)
 \gnd! ;
inout  (*
integer inh_conn_prop_name = "power_vdd3";

integer inh_conn_def_value = "cds_globals.\\vdd3! ";
 *)
 \vdd3! ;

parameter lc=2.7e-07;
parameter GT_PDW="";
parameter sx=4.8e-07;
parameter GT_PDL=350.00n;
parameter GT_PUW="";
parameter GT_PUL=300.00n;

ne3 #(.m(1 * 1), .ad(sx * GT_PDW), .nrd(lc / GT_PDW), .extlay(0), .xf_subext(0),
 .pd(2 * sx + GT_PDW), .w(GT_PDW), .par1((1 * 1)), .as(sx * GT_PDW), .nrs(lc / GT_PDW),
 .ps(2 * sx + GT_PDW), .l(GT_PDL)) (*
integer library_binding
 = "PRIMLIB";
integer passed_mfactor = "m";
 *)
MN1 ( out, in, \gnd! ,
\gnd!  );

pe3 #(.m(1 * 1), .ad(sx * GT_PUW), .nrd(lc / GT_PUW), .pd(2 * sx + GT_PUW),
 .w(GT_PUW), .par1((1 * 1)), .as(sx * GT_PUW), .nrs(lc / GT_PUW), .ps(2 * sx + GT_PUW),
 .l(GT_PUL)) (*
integer library_binding = "PRIMLIB";
integer
passed_mfactor = "m";
 *)
MP1 ( out, in, \vdd3! , \vdd3!  );

endmodule
