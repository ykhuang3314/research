// Verilog-AMS netlist generated by the AMS netlister, version  IC6.1.7-64b.500.9 .
// Cadence Design Systems, Inc.

`include "disciplines.vams"

(* cds_ams_schematic *)
module IN_3VX2 ( A,.gnd(\gnd! ),Q,.vdd3(
\vdd3! ) );

input   A;
inout  (*
integer inh_conn_prop_name = "ground_gnd";

integer inh_conn_def_value = "cds_globals.\\gnd! ";
 *)
 \gnd! ;

output   Q;
inout  (*
integer inh_conn_prop_name = "power_vdd3";

integer inh_conn_def_value = "cds_globals.\\vdd3! ";
 *)
 \vdd3! ;

invrv3 #(.lc(2.7e-07), .GT_PDW(960.00n), .sx(4.8e-07), .GT_PUW(2.94u))
(*
integer library_binding = "GATES_3V";
 *)
invr_1 ( .in( A ), .out(
Q ) );

endmodule
