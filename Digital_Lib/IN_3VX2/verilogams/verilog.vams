//Verilog-AMS HDL for "D_CELLS_3V", "IN_3VX2" "verilogams"

`include "constants.vams"
`include "disciplines.vams"

// Created by ihdl
`timescale 1ns/10ps

`celldefine

module IN_3VX2 (A, Q);
//*****************************************************************
//   technology       : 180 nm bulk CMOS
//   module name      : IN_3VX2
//   version          : 2.1.0, Mon Mar  5 07:15:19 2018
//   cell_description : Inverter
//   last modified by : XLICDD generated
//****************************************************************************
input (* integer supplySensitivity="\\vdd3! "; integer groundSensitivity="\\gnd! "; *) A;
output (* integer supplySensitivity="\\vdd3! "; integer groundSensitivity="\\gnd! "; *) Q;
electrical (* integer inh_conn_prop_name="ground_gnd"; integer inh_conn_def_value="cds_globals.\\gnd! "; *) \gnd! ;
electrical (* integer inh_conn_prop_name="power_vdd3"; integer inh_conn_def_value="cds_globals.\\vdd3! "; *) \vdd3! ;

// Function Q: !(A)
   not       i0  (Q, A);

// timing section:
   specify

      (A -=> Q) = (0.02, 0.02);

   endspecify

endmodule

`endcelldefine
