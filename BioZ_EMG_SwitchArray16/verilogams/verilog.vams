//Verilog-AMS HDL for "BioZ_EMG_Model", "BioZ_EMG_SwitchArray16" "verilogams"

`include "constants.vams"
`include "disciplines.vams"

module BioZ_EMG_SwitchArray16 ( EMG_Ch1, EMG_Ch2, EMG_Ch3, EMG_Ch4, EMG_Ch5, EMG_Ch6, EMG_Ch7, EMG_Ch8, EMG_Ch9,
							EMG_Ch10, EMG_Ch11, EMG_Ch12, EMG_Ch13, EMG_Ch14, EMG_Ch15, EMG_Ch16, BI_Ip, BI_In, BI_Vp, BI_Vn,
							E00, E01, E02, E03, E10, E11, E12, E13, E20, E21, E22, E23, E30, E31, E32, E33,
							Dir, Row, Col, Vdda, Vssa, Vsub, Vddd, Vssd);

// characteristics of switches
parameter real ron = 1 from [1:inf); 		// on resistance
parameter real roff = 1G from [1:inf); 	// off resistance
parameter real rgnd = 1G from [1:inf); 		// path to gnd resistance
parameter real tr = 200n; // rise time
parameter real tf = 200n; // fall time
parameter real td = 0; // delay

//IO ports declaration
inout 	EMG_Ch1, EMG_Ch2, EMG_Ch3, EMG_Ch4, EMG_Ch5, EMG_Ch6, EMG_Ch7, EMG_Ch8, EMG_Ch9,
		EMG_Ch10, EMG_Ch11, EMG_Ch12, EMG_Ch13, EMG_Ch14, EMG_Ch15, EMG_Ch16,
		BI_Ip, BI_In, BI_Vp, BI_Vn, E00, E01, E02, E03, E10, E11, E12, E13, E20, E21, E22, E23, E30, E31, E32, E33;
input 	Dir;
input[1:0] Row, Col;
inout Vdda, Vssa, Vsub, Vddd, Vssd;

// Type of ports
electrical 	EMG_Ch1, EMG_Ch2, EMG_Ch3, EMG_Ch4, EMG_Ch5, EMG_Ch6, EMG_Ch7, EMG_Ch8, EMG_Ch9,
			EMG_Ch10, EMG_Ch11, EMG_Ch12, EMG_Ch13, EMG_Ch14, EMG_Ch15, EMG_Ch16,
			BI_Ip, BI_In, BI_Vp, BI_Vn, E00, E01, E02, E03, E10, E11, E12,
			E13, E20, E21, E22, E23, E30, E31, E32, E33, Vdda, Vssa, Vsub, Vddd, Vssd;

// Effective only when BI mode is chosen
logic Dir; 		// Direction of current injection and voltage sensing (1: parallel to fiber; 0: perpendicular fiber)
logic Dis; 		// Distance of BI measurement (0: long; 1: short)
logic [1:0] Row; 	// Row selection
logic [1:0] Col; 	// Column selection

analog begin
	V(E00, EMG_Ch1) <+ I(E00, EMG_Ch1)*ron;
	V(E01, EMG_Ch2) <+ I(E01, EMG_Ch2)*ron;
	V(E02, EMG_Ch3) <+ I(E02, EMG_Ch3)*ron;
	V(E03, EMG_Ch4) <+ I(E03, EMG_Ch4)*ron;
	V(E10, EMG_Ch5) <+ I(E10, EMG_Ch5)*ron;
	V(E11, EMG_Ch6) <+ I(E11, EMG_Ch6)*ron;
	V(E12, EMG_Ch7) <+ I(E12, EMG_Ch7)*ron;
	V(E13, EMG_Ch8) <+ I(E13, EMG_Ch8)*ron;
	V(E20, EMG_Ch9) <+ I(E20, EMG_Ch9)*ron;
	V(E21, EMG_Ch10) <+ I(E21, EMG_Ch10)*ron;
	V(E22, EMG_Ch11) <+ I(E22, EMG_Ch11)*ron;
	V(E23, EMG_Ch12) <+ I(E23, EMG_Ch12)*ron;
	V(E30, EMG_Ch13) <+ I(E30, EMG_Ch13)*ron;
	V(E31, EMG_Ch14) <+ I(E31, EMG_Ch14)*ron;
	V(E32, EMG_Ch15) <+ I(E32, EMG_Ch15)*ron;
	V(E33, EMG_Ch16) <+ I(E33, EMG_Ch16)*ron;

	if (Dir == 1'b1) begin
		case(Row)
			2'b00: begin
				V(E00,BI_Ip) <+ 0;
				V(E01,BI_Vp) <+ 0;
				V(E02,BI_Vn) <+ 0;
				V(E03,BI_In) <+ 0;
				V(E10,BI_Ip) <+ I(E10,BI_Ip)*roff;
				V(E11,BI_Vp) <+ I(E11,BI_Vp)*roff;
				V(E12,BI_Vn) <+ I(E12,BI_Vn)*roff;
				V(E13,BI_In) <+ I(E13,BI_In)*roff;
				V(E20,BI_Ip) <+ I(E20,BI_Ip)*roff;
				V(E21,BI_Vp) <+ I(E21,BI_Vp)*roff;
				V(E22,BI_Vn) <+ I(E22,BI_Vn)*roff;
				V(E23,BI_In) <+ I(E23,BI_In)*roff;
				V(E30,BI_Ip) <+ I(E30,BI_Ip)*roff;
				V(E31,BI_Vp) <+ I(E31,BI_Vp)*roff;
				V(E32,BI_Vn) <+ I(E32,BI_Vn)*roff;
				V(E33,BI_In) <+ I(E33,BI_In)*roff;
			end
			2'b01: begin
				V(E00,BI_Ip) <+ I(E00,BI_Ip)*roff;
				V(E01,BI_Vp) <+ I(E01,BI_Vp)*roff;
				V(E02,BI_Vn) <+ I(E02,BI_Vn)*roff;
				V(E03,BI_In) <+ I(E03,BI_In)*roff;
				V(E10,BI_Ip) <+ 0;
				V(E11,BI_Vp) <+ 0;
				V(E12,BI_Vn) <+ 0;
				V(E13,BI_In) <+ 0;
				V(E20,BI_Ip) <+ I(E20,BI_Ip)*roff;
				V(E21,BI_Vp) <+ I(E21,BI_Vp)*roff;
				V(E22,BI_Vn) <+ I(E22,BI_Vn)*roff;
				V(E23,BI_In) <+ I(E23,BI_In)*roff;
				V(E30,BI_Ip) <+ I(E30,BI_Ip)*roff;
				V(E31,BI_Vp) <+ I(E31,BI_Vp)*roff;
				V(E32,BI_Vn) <+ I(E32,BI_Vn)*roff;
				V(E33,BI_In) <+ I(E33,BI_In)*roff;
			end
			2'b10: begin
				V(E00,BI_Ip) <+ I(E00,BI_Ip)*roff;
				V(E01,BI_Vp) <+ I(E01,BI_Vp)*roff;
				V(E02,BI_Vn) <+ I(E02,BI_Vn)*roff;
				V(E03,BI_In) <+ I(E03,BI_In)*roff;
				V(E10,BI_Ip) <+ I(E10,BI_Ip)*roff;
				V(E11,BI_Vp) <+ I(E11,BI_Vp)*roff;
				V(E12,BI_Vn) <+ I(E12,BI_Vn)*roff;
				V(E13,BI_In) <+ I(E13,BI_In)*roff;
				V(E20,BI_Ip) <+ 0;
				V(E21,BI_Vp) <+ 0;
				V(E22,BI_Vn) <+ 0;
				V(E23,BI_In) <+ 0;
				V(E30,BI_Ip) <+ I(E30,BI_Ip)*roff;
				V(E31,BI_Vp) <+ I(E31,BI_Vp)*roff;
				V(E32,BI_Vn) <+ I(E32,BI_Vn)*roff;
				V(E33,BI_In) <+ I(E33,BI_In)*roff;
			end
			2'b11: begin
				V(E00,BI_Ip) <+ I(E00,BI_Ip)*roff;
				V(E01,BI_Vp) <+ I(E01,BI_Vp)*roff;
				V(E02,BI_Vn) <+ I(E02,BI_Vn)*roff;
				V(E03,BI_In) <+ I(E03,BI_In)*roff;
				V(E10,BI_Ip) <+ I(E10,BI_Ip)*roff;
				V(E11,BI_Vp) <+ I(E11,BI_Vp)*roff;
				V(E12,BI_Vn) <+ I(E12,BI_Vn)*roff;
				V(E13,BI_In) <+ I(E13,BI_In)*roff;
				V(E20,BI_Ip) <+ I(E20,BI_Ip)*roff;
				V(E21,BI_Vp) <+ I(E21,BI_Vp)*roff;
				V(E22,BI_Vn) <+ I(E22,BI_Vn)*roff;
				V(E23,BI_In) <+ I(E23,BI_In)*roff;
				V(E30,BI_Ip) <+ 0;
				V(E31,BI_Vp) <+ 0;
				V(E32,BI_Vn) <+ 0;
				V(E33,BI_In) <+ 0;
			end
		endcase
	end
	else if (Dir == 1'b0) begin
		case(Col)
			2'b00: begin
				V(E00,BI_Ip) <+ 0;
				V(E01,BI_Vp) <+ I(E01,BI_Vp)*roff;
				V(E02,BI_Vn) <+ I(E02,BI_Vn)*roff;
				V(E03,BI_In) <+ I(E03,BI_In)*roff;
				V(E10,BI_Ip) <+ 0;
				V(E11,BI_Vp) <+ I(E11,BI_Vp)*roff;
				V(E12,BI_Vn) <+ I(E12,BI_Vn)*roff;
				V(E13,BI_In) <+ I(E13,BI_In)*roff;
				V(E20,BI_Ip) <+ 0;
				V(E21,BI_Vp) <+ I(E21,BI_Vp)*roff;
				V(E22,BI_Vn) <+ I(E22,BI_Vn)*roff;
				V(E23,BI_In) <+ I(E23,BI_In)*roff;
				V(E30,BI_Ip) <+ 0;
				V(E31,BI_Vp) <+ I(E31,BI_Vp)*roff;
				V(E32,BI_Vn) <+ I(E32,BI_Vn)*roff;
				V(E33,BI_In) <+ I(E33,BI_In)*roff;
			end
			2'b01: begin
				V(E00,BI_Ip) <+ I(E00,BI_Ip)*roff;
				V(E01,BI_Vp) <+ 0;
				V(E02,BI_Vn) <+ I(E02,BI_Vn)*roff;
				V(E03,BI_In) <+ I(E03,BI_In)*roff;
				V(E10,BI_Ip) <+ I(E10,BI_Ip)*roff;
				V(E11,BI_Vp) <+ 0;
				V(E12,BI_Vn) <+ I(E12,BI_Vn)*roff;
				V(E13,BI_In) <+ I(E13,BI_In)*roff;
				V(E20,BI_Ip) <+ I(E20,BI_Ip)*roff;
				V(E21,BI_Vp) <+ 0;
				V(E22,BI_Vn) <+ I(E22,BI_Vn)*roff;
				V(E23,BI_In) <+ I(E23,BI_In)*roff;
				V(E30,BI_Ip) <+ I(E30,BI_Ip)*roff;
				V(E31,BI_Vp) <+ 0;
				V(E32,BI_Vn) <+ I(E32,BI_Vn)*roff;
				V(E33,BI_In) <+ I(E33,BI_In)*roff;
			end
			2'b10: begin
				V(E00,BI_Ip) <+ I(E00,BI_Ip)*roff;
				V(E01,BI_Vp) <+ I(E01,BI_Vp)*roff;
				V(E02,BI_Vn) <+ 0;
				V(E03,BI_In) <+ I(E03,BI_In)*roff;
				V(E10,BI_Ip) <+ I(E10,BI_Ip)*roff;
				V(E11,BI_Vp) <+ I(E11,BI_Vp)*roff;
				V(E12,BI_Vn) <+ 0;
				V(E13,BI_In) <+ I(E13,BI_In)*roff;
				V(E20,BI_Ip) <+ I(E20,BI_Ip)*roff;
				V(E21,BI_Vp) <+ I(E21,BI_Vp)*roff;
				V(E22,BI_Vn) <+ 0;
				V(E23,BI_In) <+ I(E23,BI_In)*roff;
				V(E30,BI_Ip) <+ I(E30,BI_Ip)*roff;
				V(E31,BI_Vp) <+ I(E31,BI_Vp)*roff;
				V(E32,BI_Vn) <+ 0;
				V(E33,BI_In) <+ I(E33,BI_In)*roff;
			end
			2'b11: begin
				V(E00,BI_Ip) <+ I(E00,BI_Ip)*roff;
				V(E01,BI_Vp) <+ I(E01,BI_Vp)*roff;
				V(E02,BI_Vn) <+ I(E02,BI_Vn)*roff;
				V(E03,BI_In) <+ 0;
				V(E10,BI_Ip) <+ I(E10,BI_Ip)*roff;
				V(E11,BI_Vp) <+ I(E11,BI_Vp)*roff;
				V(E12,BI_Vn) <+ I(E12,BI_Vn)*roff;
				V(E13,BI_In) <+ 0;
				V(E20,BI_Ip) <+ I(E20,BI_Ip)*roff;
				V(E21,BI_Vp) <+ I(E21,BI_Vp)*roff;
				V(E22,BI_Vn) <+ I(E22,BI_Vn)*roff;
				V(E23,BI_In) <+ 0;
				V(E30,BI_Ip) <+ I(E30,BI_Ip)*1e9;
				V(E31,BI_Vp) <+ I(E31,BI_Vp)*1e9;
				V(E32,BI_Vn) <+ I(E32,BI_Vn)*roff;
				V(E33,BI_In) <+ 0;
			end
		endcase
	end
end

endmodule
