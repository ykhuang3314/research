//Verilog-AMS HDL for "BioZ_EMG_Model", "BioZ_PLL_VCO" "verilogams"
//Voltage Controlled Oscillator
/*
 * 32 MHz VCO
 *
 * Author: Saul Rodriguez
 * Date: 2015-06-17
 *
 * Description:
 * This VCO has a TT free running frequency of around 28.5 MHz when the control voltage is 1V.
 * The VCO's gain is 19.2 MHz/V.
 * The VerilogA model is a modified version of the model taken from "The Designers's Guide to Verilog-AMS, 2004"
 */

`include "constants.vams"
`include "disciplines.vams"

module BioZ_PLL_VCO ( Vout, Vctrl, bias_in, vdda, vssa, vsub );

  input vsub;
  input vdda;
  input bias_in;
  input Vctrl;
  input vssa;
  output Vout;

  electrical Vctrl, Vout;

  parameter real vmin=0.5;				// input voltage that corresponds to minimum output frequency
  parameter real vmax=1.5 from (vmin:inf);	// input voltage that corresponds to maximum output frequency
  parameter real fmin=10.3M from (0:inf);		// minimum output frequency
  parameter real fmax=37.5M from (fmin:inf);	// maximum output frequency
  parameter real vl=0;				// low output voltage
  parameter real vh=1.8;				// high output voltage
  parameter real tt=0.01/fmax from (0:inf);	// output transition time
  parameter real ttol=1u/fmax from (0:1/fmax);	// time tolerance
  real freq, phase;
  integer n;

analog begin
    // compute the freq from the input voltage
    freq = (V(Vctrl) - vmin)*(fmax - fmin) / (vmax - vmin) + fmin;

    // bound the frequency (this is optional)
    if (freq > fmax) freq = fmax;
    if (freq < fmin) freq = fmin;

    // bound the time step to assure no cycles are skipped
    $bound_step(0.6/freq);

    // phase is the integral of the freq modulo 2p
    phase = 2*`M_PI*idtmod(freq, 0.0, 1.0, -0.5);

    // identify the point where switching occurs
    @(cross(phase + `M_PI/2, +1, ttol) or cross(phase - `M_PI/2, +1, ttol))
	n = (phase >= -`M_PI/2) && (phase < `M_PI/2);

    // generate the output
    V(Vout) <+ transition(n ? vh : vl, 0, tt);
end

endmodule
