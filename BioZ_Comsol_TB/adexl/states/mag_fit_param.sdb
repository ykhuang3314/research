ADE simulation setup
Global variables:
  a1_arm_2cm = 0.95
  a1_arm_4cm = 0.91
  a1_leg_2cm = 0.97
  a1_leg_4cm = 0.93
  a2_arm_2cm = 0.8
  a2_arm_4cm = 0.78
  a2_leg_2cm = 0.78
  a2_leg_4cm = 0.86
  a3_arm_2cm = 0.9999
  a3_arm_4cm = 0.9999
  a3_leg_2cm = 0.84
  a3_leg_4cm = 0.79
  R1_arm_2cm = 34
  R1_arm_4cm = 50
  R1_leg_2cm = 10
  R1_leg_4cm = 11
  R2_arm_2cm = 46
  R2_arm_4cm = 46
  R2_leg_2cm = 20
  R2_leg_4cm = 10
  R3_arm_2cm = 8
  R3_arm_4cm = 7
  R3_leg_2cm = 3
  R3_leg_4cm = 2
  Rinf_arm_2cm = 5
  Rinf_arm_4cm = 6
  Rinf_leg_2cm = 3
  Rinf_leg_4cm = 4
  Z1_arm_2cm = 6.5k
  Z1_arm_4cm = 9k
  Z1_leg_2cm = 1.6k
  Z1_leg_4cm = 2.5k
  Z2_arm_2cm = 1.5M
  Z2_arm_4cm = 1.5M
  Z2_leg_2cm = 600k
  Z2_leg_4cm = 1.7M
  Z3_arm_2cm = 70k
  Z3_arm_4cm = 70k
  Z3_leg_2cm = 15k
  Z3_leg_4cm = 10k
Device parameters:
  BioZ_EMG_Model/BioZ_Comsol_TB/schematic/Rinf_arm_2cm.r = 5
  BioZ_EMG_Model/BioZ_Comsol_TB/schematic/R1_arm_2cm.r = 34
  BioZ_EMG_Model/BioZ_Comsol_TB/schematic/R2_arm_2cm.r = 46
  BioZ_EMG_Model/BioZ_Comsol_TB/schematic/R3_arm_2cm.r = 8
  BioZ_EMG_Model/BioZ_Comsol_TB/schematic/Rinf_arm_4cm.r = 6
  BioZ_EMG_Model/BioZ_Comsol_TB/schematic/R1_arm_4cm.r = 50
  BioZ_EMG_Model/BioZ_Comsol_TB/schematic/R2_arm_4cm.r = 46
  BioZ_EMG_Model/BioZ_Comsol_TB/schematic/R3_arm_4cm.r = 7
  BioZ_EMG_Model/BioZ_Comsol_TB/schematic/Rinf_leg_2cm.r = 3
  BioZ_EMG_Model/BioZ_Comsol_TB/schematic/R1_leg_2cm.r = 10
  BioZ_EMG_Model/BioZ_Comsol_TB/schematic/R2_leg_2cm.r = 20
  BioZ_EMG_Model/BioZ_Comsol_TB/schematic/R3_leg_2cm.r = 3
  BioZ_EMG_Model/BioZ_Comsol_TB/schematic/Rinf_leg_4cm.r = 4
  BioZ_EMG_Model/BioZ_Comsol_TB/schematic/R1_leg_4cm.r = 11
  BioZ_EMG_Model/BioZ_Comsol_TB/schematic/R2_leg_4cm.r = 10
  BioZ_EMG_Model/BioZ_Comsol_TB/schematic/R3_leg_4cm.r = 2
  BioZ_EMG_Model/BioZ_Comsol_TB/schematic/FP1_arm_2cm.coef = 6.5k
  BioZ_EMG_Model/BioZ_Comsol_TB/schematic/FP1_arm_2cm.slope = -0.95
  BioZ_EMG_Model/BioZ_Comsol_TB/schematic/FP2_arm_2cm.coef = 1.5M
  BioZ_EMG_Model/BioZ_Comsol_TB/schematic/FP2_arm_2cm.slope = -0.8
  BioZ_EMG_Model/BioZ_Comsol_TB/schematic/FP3_arm_2cm.coef = 70k
  BioZ_EMG_Model/BioZ_Comsol_TB/schematic/FP3_arm_2cm.slope = -0.9999
  BioZ_EMG_Model/BioZ_Comsol_TB/schematic/FP1_arm_4cm.coef = 9k
  BioZ_EMG_Model/BioZ_Comsol_TB/schematic/FP1_arm_4cm.slope = -0.91
  BioZ_EMG_Model/BioZ_Comsol_TB/schematic/FP2_arm_4cm.coef = 1.5M
  BioZ_EMG_Model/BioZ_Comsol_TB/schematic/FP2_arm_4cm.slope = -0.78
  BioZ_EMG_Model/BioZ_Comsol_TB/schematic/FP3_arm_4cm.coef = 70k
  BioZ_EMG_Model/BioZ_Comsol_TB/schematic/FP3_arm_4cm.slope = -0.9999
  BioZ_EMG_Model/BioZ_Comsol_TB/schematic/FP1_leg_2cm.coef = 1.6k
  BioZ_EMG_Model/BioZ_Comsol_TB/schematic/FP1_leg_2cm.slope = -0.97
  BioZ_EMG_Model/BioZ_Comsol_TB/schematic/FP2_leg_2cm.coef = 600k
  BioZ_EMG_Model/BioZ_Comsol_TB/schematic/FP2_leg_2cm.slope = -0.78
  BioZ_EMG_Model/BioZ_Comsol_TB/schematic/FP3_leg_2cm.coef = 15k
  BioZ_EMG_Model/BioZ_Comsol_TB/schematic/FP3_leg_2cm.slope = -0.84
  BioZ_EMG_Model/BioZ_Comsol_TB/schematic/FP1_leg_4cm.coef = 2.5k
  BioZ_EMG_Model/BioZ_Comsol_TB/schematic/FP1_leg_4cm.slope = -0.93
  BioZ_EMG_Model/BioZ_Comsol_TB/schematic/FP2_leg_4cm.coef = 1.7M
  BioZ_EMG_Model/BioZ_Comsol_TB/schematic/FP2_leg_4cm.slope = -0.86
  BioZ_EMG_Model/BioZ_Comsol_TB/schematic/FP3_leg_4cm.coef = 10k
  BioZ_EMG_Model/BioZ_Comsol_TB/schematic/FP3_leg_4cm.slope = -0.79
