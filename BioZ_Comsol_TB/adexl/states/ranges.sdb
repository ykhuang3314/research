ADE simulation setup
Global variables:
  a1 = 0.91
  a2 = 0.78
  a3 = 0.9999
  R1 = 35
  R2 = 44
  R3 = 7
  Rinf = 8
  Z1 = 5e3
  Z2 = 1e6
  Z3 = 7e4
Device parameters:
  BioZ_EMG_Model/BioZ_Comsol_TB/schematic/Rinf_arm_2cm.r = 1:1:15
  BioZ_EMG_Model/BioZ_Comsol_TB/schematic/R1_arm_2cm.r = 20:1:50
  BioZ_EMG_Model/BioZ_Comsol_TB/schematic/R2_arm_2cm.r = 20:1:50
  BioZ_EMG_Model/BioZ_Comsol_TB/schematic/R3_arm_2cm.r = 1:1:15
  BioZ_EMG_Model/BioZ_Comsol_TB/schematic/Rinf_arm_4cm.r = 1:1:15
  BioZ_EMG_Model/BioZ_Comsol_TB/schematic/R1_arm_4cm.r = 20:1:50
  BioZ_EMG_Model/BioZ_Comsol_TB/schematic/R2_arm_4cm.r = 20:1:50
  BioZ_EMG_Model/BioZ_Comsol_TB/schematic/R3_arm_4cm.r = 1:1:15
  BioZ_EMG_Model/BioZ_Comsol_TB/schematic/Rinf_leg_2cm.r = 1:1:15
  BioZ_EMG_Model/BioZ_Comsol_TB/schematic/R1_leg_2cm.r = 20:1:50
  BioZ_EMG_Model/BioZ_Comsol_TB/schematic/R2_leg_2cm.r = 20:1:50
  BioZ_EMG_Model/BioZ_Comsol_TB/schematic/R3_leg_2cm.r = 1:1:15
  BioZ_EMG_Model/BioZ_Comsol_TB/schematic/Rinf_leg_4cm.r = 1:1:15
  BioZ_EMG_Model/BioZ_Comsol_TB/schematic/R1_leg_4cm.r = 20:1:50
  BioZ_EMG_Model/BioZ_Comsol_TB/schematic/R2_leg_4cm.r = 20:1:50
  BioZ_EMG_Model/BioZ_Comsol_TB/schematic/R3_leg_4cm.r = 1:1:15
  BioZ_EMG_Model/BioZ_Comsol_TB/schematic/FP1_arm_2cm.coef = 1k:1k:10k
  BioZ_EMG_Model/BioZ_Comsol_TB/schematic/FP1_arm_2cm.slope = -0.5:0.05:0.9999
  BioZ_EMG_Model/BioZ_Comsol_TB/schematic/FP2_arm_2cm.coef = 100k:100k:1M
  BioZ_EMG_Model/BioZ_Comsol_TB/schematic/FP2_arm_2cm.slope = -0.5:0.05:0.9999
  BioZ_EMG_Model/BioZ_Comsol_TB/schematic/FP3_arm_2cm.coef = 10k:10k:100k
  BioZ_EMG_Model/BioZ_Comsol_TB/schematic/FP3_arm_2cm.slope = -0.5:0.05:0.9999
  BioZ_EMG_Model/BioZ_Comsol_TB/schematic/FP1_arm_4cm.coef = 1k:1k:10k
  BioZ_EMG_Model/BioZ_Comsol_TB/schematic/FP1_arm_4cm.slope = -0.5:0.05:0.9999
  BioZ_EMG_Model/BioZ_Comsol_TB/schematic/FP2_arm_4cm.coef = 100k:100k:1M
  BioZ_EMG_Model/BioZ_Comsol_TB/schematic/FP2_arm_4cm.slope = -0.5:0.05:0.9999
  BioZ_EMG_Model/BioZ_Comsol_TB/schematic/FP3_arm_4cm.coef = 10k:10k:100k
  BioZ_EMG_Model/BioZ_Comsol_TB/schematic/FP3_arm_4cm.slope = -0.5:0.05:0.9999
  BioZ_EMG_Model/BioZ_Comsol_TB/schematic/FP1_leg_2cm.coef = 1k:1k:10k
  BioZ_EMG_Model/BioZ_Comsol_TB/schematic/FP1_leg_2cm.slope = -0.5:0.05:0.9999
  BioZ_EMG_Model/BioZ_Comsol_TB/schematic/FP2_leg_2cm.coef = 100k:100k:1M
  BioZ_EMG_Model/BioZ_Comsol_TB/schematic/FP2_leg_2cm.slope = -0.5:0.05:0.9999
  BioZ_EMG_Model/BioZ_Comsol_TB/schematic/FP3_leg_2cm.coef = 10k:10k:100k
  BioZ_EMG_Model/BioZ_Comsol_TB/schematic/FP3_leg_2cm.slope = -0.5:0.05:0.9999
  BioZ_EMG_Model/BioZ_Comsol_TB/schematic/FP1_leg_4cm.coef = 1k:1k:10k
  BioZ_EMG_Model/BioZ_Comsol_TB/schematic/FP1_leg_4cm.slope = -0.5:0.05:0.9999
  BioZ_EMG_Model/BioZ_Comsol_TB/schematic/FP2_leg_4cm.coef = 100k:100k:1M
  BioZ_EMG_Model/BioZ_Comsol_TB/schematic/FP2_leg_4cm.slope = -0.5:0.05:0.9999
  BioZ_EMG_Model/BioZ_Comsol_TB/schematic/FP3_leg_4cm.coef = 10k:10k:100k
  BioZ_EMG_Model/BioZ_Comsol_TB/schematic/FP3_leg_4cm.slope = -0.5:0.05:0.9999
