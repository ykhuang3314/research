//Verilog-AMS HDL for "EMG_Model", "SwitchArray16_EMG_BI" "verilogams"

`include "constants.vams"
`include "disciplines.vams"

module SwitchArray16_EMG_BI (EMG_Ch1, EMG_Ch2, EMG_Ch3, EMG_Ch4, EMG_Ch5, EMG_Ch6, EMG_Ch7, EMG_Ch8, EMG_Ch9,
							EMG_Ch10, EMG_Ch11, EMG_Ch12, EMG_Ch13, EMG_Ch14, EMG_Ch15, EMG_Ch16, BI_Ip, BI_In, BI_Vp, BI_Vn,
							E00, E01, E02, E03, E10, E11, E12, E13, E20, E21, E22, E23, E30, E31, E32, E33,
							Dir, Row, Col, Vdda, Vssa, Vsub, Vddd, Vssd);

// characteristics of switches
parameter real Ron = 10 from [1:inf); 		// on resistance
parameter real Roff = 100M from [1:inf); 	// off resistance

//IO ports declaration
inout 	EMG_Ch1, EMG_Ch2, EMG_Ch3, EMG_Ch4, EMG_Ch5, EMG_Ch6, EMG_Ch7, EMG_Ch8, EMG_Ch9,
		EMG_Ch10, EMG_Ch11, EMG_Ch12, EMG_Ch13, EMG_Ch14, EMG_Ch15, EMG_Ch16,
		BI_Ip, BI_In, BI_Vp, BI_Vn;
input 	E00, E01, E02, E03, E10, E11, E12, E13, E20, E21, E22, E23, E30, E31, E32, E33, Dir;
input[1:0] Row, Col;
inout Vdda, Vssa, Vsub, Vddd, Vssd;

// Type of ports
electrical 	EMG_Ch1, EMG_Ch2, EMG_Ch3, EMG_Ch4, EMG_Ch5, EMG_Ch6, EMG_Ch7, EMG_Ch8, EMG_Ch9,
			EMG_Ch10, EMG_Ch11, EMG_Ch12, EMG_Ch13, EMG_Ch14, EMG_Ch15, EMG_Ch16,
			BI_Ip, BI_In, BI_Vp, BI_Vn, E00, E01, E02, E03, E10, E11, E12,
			E13, E20, E21, E22, E23, E30, E31, E32, E33, Vdda, Vssa, Vsub, Vddd, Vssd;

// Effective only when BI mode is chosen
wire Dir; 		// Direction of current injection and voltage sensing (1: parallel to fiber; 0: perpendicular fiber)
wire Dis; 		// Distance of BI measurement (0: long; 1: short)
wire[1:0] Row; 	// Row selection
wire[1:0] Col; 	// Column selection

//internal variables
integer C_int, R_int;

always@(Row or Col) begin

	if(Dir == 1'b0) begin 	// perpendicular to fiber
		C_int = 2*Col[1] + Col[0];
	end else begin
		R_int = 2*Row[1] + Row[0];
	end

end

analog begin

	I(E00, EMG_Ch1) <+ V(E00, EMG_Ch1)/Ron;
	I(E01, EMG_Ch2) <+ V(E01, EMG_Ch2)/Ron;
	I(E02, EMG_Ch3) <+ V(E02, EMG_Ch3)/Ron;
	I(E03, EMG_Ch4) <+ V(E03, EMG_Ch4)/Ron;
	I(E10, EMG_Ch5) <+ V(E10, EMG_Ch5)/Ron;
	I(E11, EMG_Ch6) <+ V(E11, EMG_Ch6)/Ron;
	I(E12, EMG_Ch7) <+ V(E12, EMG_Ch7)/Ron;
	I(E13, EMG_Ch8) <+ V(E13, EMG_Ch8)/Ron;
	I(E20, EMG_Ch9) <+ V(E20, EMG_Ch9)/Ron;
	I(E21, EMG_Ch10) <+ V(E21, EMG_Ch10)/Ron;
	I(E22, EMG_Ch11) <+ V(E22, EMG_Ch11)/Ron;
	I(E23, EMG_Ch12) <+ V(E23, EMG_Ch12)/Ron;
	I(E30, EMG_Ch13) <+ V(E30, EMG_Ch13)/Ron;
	I(E31, EMG_Ch14) <+ V(E31, EMG_Ch14)/Ron;
	I(E32, EMG_Ch15) <+ V(E32, EMG_Ch15)/Ron;
	I(E33, EMG_Ch16) <+ V(E33, EMG_Ch16)/Ron;

	if(Dir == 1'b0) begin // perpendicular
		case(C_int) // selected column
			0 : begin
					V(BI_Ip, E00) <+ I(BI_Ip, E00)*Ron;
					V(E30, BI_In) <+ I(E30, BI_In)*Ron;
					I(E10, BI_Vp) <+ V(E10, BI_Vp)/Ron;
				 	I(E20, BI_Vn) <+ V(E20, BI_Vn)/Ron;
				end

			1 : begin
					V(BI_Ip, E01) <+ I(BI_Ip, E01)*Ron;
					V(E31, BI_In) <+ I(E31, BI_In)*Ron;
					I(E11, BI_Vp) <+ V(E11, BI_Vp)/Ron;
					I(E21, BI_Vn) <+ V(E21, BI_Vn)/Ron;
				end

			2 : begin
					V(BI_Ip, E02) <+ I(BI_Ip, E02)*Ron;
					V(E32, BI_In) <+ I(E32, BI_In)*Ron;
					I(E12, BI_Vp) <+ V(E12, BI_Vp)/Ron;
					I(E22, BI_Vn) <+ V(E22, BI_Vn)/Ron;
				end

			3 : begin
					V(BI_Ip, E03) <+ I(BI_Ip, E03)*Ron;
					V(E33, BI_In) <+ I(E33, BI_In)*Ron;
					I(E13, BI_Vp) <+ V(E13, BI_Vp)/Ron;
					I(E23, BI_Vn) <+ V(E23, BI_Vn)/Ron;
				end
		endcase
	end else begin // parallel
		case(R_int) // selected row
			0 : begin
					V(BI_Ip, E00) <+ I(BI_Ip, E00)*Ron;
					V(E03, BI_In) <+ I(E03, BI_In)*Ron;
					I(E01, BI_Vp) <+ V(E01, BI_Vp)/Ron;
				 	I(E02, BI_Vn) <+ V(E02, BI_Vn)/Ron;
				end

			1 : begin
					V(BI_Ip, E10) <+ I(BI_Ip, E10)*Ron;
					V(E13, BI_In) <+ I(E13, BI_In)*Ron;
					I(E11, BI_Vp) <+ V(E11, BI_Vp)/Ron;
					I(E12, BI_Vn) <+ V(E12, BI_Vn)/Ron;
				end

			2 : begin
					V(BI_Ip, E20) <+ I(BI_Ip, E20)*Ron;
					V(E23, BI_In) <+ I(E23, BI_In)*Ron;
					I(E21, BI_Vp) <+ V(E21, BI_Vp)/Ron;
					I(E22, BI_Vn) <+ V(E22, BI_Vn)/Ron;
				end

			3 : begin
					V(BI_Ip, E30) <+ I(BI_Ip, E30)*Ron;
					V(E33, BI_In) <+ I(E33, BI_In)*Ron;
					I(E31, BI_Vp) <+ V(E31, BI_Vp)/Ron;
					I(E32, BI_Vn) <+ V(E32, BI_Vn)/Ron;
				end
		endcase
	end
end

endmodule
