//Verilog-AMS HDL for "BioZ_EMG_Model", "BioZ_SigGen_LPF" "verilogams"

`include "constants.vams"
`include "disciplines.vams"

module BioZ_SigGen_LPF ( VOUT_N, VOUT_P, VIN_N, VIN_P, bias_in, vdda, vddd, vssa, vssd, vsub , fc_sel);

  input vsub;
  input vssa;
  input vssd;
  input vdda;
  input vddd;
  input bias_in;
  input VIN_P;
  input VIN_N;
  output VOUT_P;
  output VOUT_N;
  input [3:0] fc_sel;

  electrical VOUT_N, VOUT_P, VIN_N, VIN_P, vssa;
  logic [3:0] fc_sel;
  real LPF_1, LPF_2, LPF_3, LPF_4, LPF_5, LPF_6, LPF_7, LPF_8, LPF_9, LPF_10, LPF_11;

  //parameter real LPF_fc = 10 from (0:50];
parameter real gm_1 = 0.5u;
parameter real C1_1 = 26.42p;
parameter real C2_1 = 14.76p;
parameter real a1_1 = C1_1/gm_1;
parameter real a2_1 = (C1_1*C2_1)/(gm_1**2);

parameter real gm_2 = 0.5u;
parameter real C1_2 = 13.20p;
parameter real C2_2 = 7.37p;
parameter real a1_2 = C1_2/gm_2;
parameter real a2_2 = (C1_2*C2_2)/(gm_2**2);

parameter real gm_3 = 0.5u;
parameter real C1_3 = 6.61p;
parameter real C2_3 = 3.69p;
parameter real a1_3 = C1_3/gm_3;
parameter real a2_3 = (C1_3*C2_3)/(gm_3**2);

parameter real gm_4 = 0.5u;
parameter real C1_4 = 3.12p;
parameter real C2_4 = 1.74p;
parameter real a1_4 = C1_4/gm_4;
parameter real a2_4 = (C1_4*C2_4)/(gm_4**2);

parameter real gm_5 = 5u;
parameter real C1_5 = 17.59p;
parameter real C2_5 = 9.82p;
parameter real a1_5 = C1_5/gm_5;
parameter real a2_5 = (C1_5*C2_5)/(gm_5**2);

parameter real gm_6 = 5u;
parameter real C1_6 = 8.49p;
parameter real C2_6 = 4.74p;
parameter real a1_6 = C1_6/gm_6;
parameter real a2_6 = (C1_6*C2_6)/(gm_6**2);

parameter real gm_7 = 5u;
parameter real C1_7 = 4.13p;
parameter real C2_7 = 2.30p;
parameter real a1_7 = C1_7/gm_7;
parameter real a2_7 = (C1_7*C2_7)/(gm_7**2);

parameter real gm_8 = 50u;
parameter real C1_8 = 22.16p;
parameter real C2_8 = 12.37p;
parameter real a1_8 = C1_8/gm_8;
parameter real a2_8 = (C1_8*C2_8)/(gm_8**2);

parameter real gm_9 = 50u;
parameter real C1_9 = 11.09p;
parameter real C2_9 = 6.19p;
parameter real a1_9 = C1_9/gm_9;
parameter real a2_9 = (C1_9*C2_9)/(gm_9**2);

parameter real gm_10 = 50u;
parameter real C1_10 = 5.60p;
parameter real C2_10 = 3.13p;
parameter real a1_10 = C1_10/gm_10;
parameter real a2_10 = (C1_10*C2_10)/(gm_10**2);

parameter real gm_11 = 50u;
parameter real C1_11 = 2.69p;
parameter real C2_11 = 1.50p;
parameter real a1_11 = C1_11/gm_11;
parameter real a2_11 = (C1_11*C2_11)/(gm_11**2);

  analog begin
	case(fc_sel)
		//LF
		4'b1010: V(VOUT_P,VOUT_N) <+ LPF_1;
		4'b1001: V(VOUT_P,VOUT_N) <+ LPF_2;
		4'b1000: V(VOUT_P,VOUT_N) <+ LPF_3;
		4'b0111: V(VOUT_P,VOUT_N) <+ LPF_4;
		//MF
		4'b0110: V(VOUT_P,VOUT_N) <+ LPF_5;
		4'b0101: V(VOUT_P,VOUT_N) <+ LPF_6;
		4'b0100: V(VOUT_P,VOUT_N) <+ LPF_7;
		//HF
		4'b0011: V(VOUT_P,VOUT_N) <+ LPF_8;
		4'b0010: V(VOUT_P,VOUT_N) <+ LPF_9;
		4'b0001: V(VOUT_P,VOUT_N) <+ LPF_10;
		4'b0000: V(VOUT_P,VOUT_N) <+ LPF_11;
		default: V(VOUT_P,VOUT_N) <+ LPF_1;
	endcase
	LPF_1 = laplace_nd(V(VIN_P,VIN_N),{1},{1,a1_1,a2_1});
	LPF_2 = laplace_nd(V(VIN_P,VIN_N),{1},{1,a1_2,a2_2});
	LPF_3 = laplace_nd(V(VIN_P,VIN_N),{1},{1,a1_3,a2_3});
	LPF_4 = laplace_nd(V(VIN_P,VIN_N),{1},{1,a1_4,a2_4});
	LPF_5 = laplace_nd(V(VIN_P,VIN_N),{1},{1,a1_5,a2_5});
	LPF_6 = laplace_nd(V(VIN_P,VIN_N),{1},{1,a1_6,a2_6});
	LPF_7 = laplace_nd(V(VIN_P,VIN_N),{1},{1,a1_7,a2_7});
	LPF_8 = laplace_nd(V(VIN_P,VIN_N),{1},{1,a1_8,a2_8});
	LPF_9 = laplace_nd(V(VIN_P,VIN_N),{1},{1,a1_9,a2_9});
	LPF_10 = laplace_nd(V(VIN_P,VIN_N),{1},{1,a1_10,a2_10});
	LPF_11 = laplace_nd(V(VIN_P,VIN_N),{1},{1,a1_11,a2_11});
  end

endmodule
