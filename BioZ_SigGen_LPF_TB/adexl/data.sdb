ADE simulation setup
Run mode: Single Run, Sweeps and Corners
Tests:
  BioZ_EMG_Model:BioZ_SigGen_LPF_TB:1: BioZ_EMG_Model/BioZ_SigGen_LPF_TB/config, simulator ams
    Outputs: VOUT_diff_ac
