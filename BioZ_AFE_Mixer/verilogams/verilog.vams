//Verilog-AMS HDL for "BioZ_EMG_Model", "BioZ_AFE_Mixer" "verilogams"

/*
 * I/Q Switching-Current Down-converter Mixer
 * Author: Saul Rodriguez
 * Date: 2015-06-10
 *
 * Description:
 * The block's input is a differential current at the RF_P RF_N ports. This current is frequency-mixed
 * with either the I_P,I_N or Q_P,Q_N clock signals. The selection of the clock signal is done by using the
 * IQ_CTRL digital input. The core of the mixer is a current switching differential
 * mixer. The output currents are available in the ports IF_P, IF_N.
 *
 */

`timescale 1ns/1ps
`include "constants.vams"
`include "disciplines.vams"

module BioZ_AFE_Mixer( IF_N, IF_P, IQ_CTRL, I_N, I_P, Q_N, Q_P, RF_N, RF_P, vddd, vssa, vssd, vsub );

  input Q_N;
  input vsub;
  output IF_N;
  input I_P;
  input IQ_CTRL;
  input vssd;
  input RF_P;
  input I_N;
  input vssa;
  input vddd;
  output IF_P;
  input RF_N;
  input Q_P;

  logic IQ_CTRL, I_N, I_P, Q_N, Q_P;
  electrical IF_N, IF_P, RF_N, RF_P, vssa;

  parameter real ron = 10; // on resistance
  parameter real roff = 100M; //off resistance
  parameter real td = 0; //delay time
  parameter real tr = 1n; //rise time
  parameter real tf = 1n; //fall time

  integer sel = 0; // sel = 0 for I path, sel = 1 for Q path
  real r1; //resistance between (RF+,IF+) and (RF-,IF-)
  real r2; //resistance between (RF+,IF-) and (RF-,IF+)

  real iin;

  //digital control block
  always@(IQ_CTRL)
  begin
	if (IQ_CTRL == 0)
		sel = 0;
	else
		sel = 1;
  end

  //analog block
  analog begin

  iin = I(RF_P,RF_N);

  if (sel == 0) begin // I path

	if(I_P) begin
		I(IF_P,IF_N) <+ -iin;
	end else begin
		I(IF_P,IF_N) <+ iin;
	end

  end else begin // Q path
	if(Q_P) begin
		I(IF_P,IF_N) <+ -iin;
	end else begin
		I(IF_P,IF_N) <+ iin;
	end
  end

/*
    @(initial_step) begin
		r1 = roff;
		r2 = roff;
	end

	@(posedge I_P) begin
		if (sel == 0) begin
			r1 = ron;
			r2 = roff;
		end
    end

	@(negedge I_P) begin
		if (sel == 0) begin
			r1 = roff;
			r2 = ron;
		end
    end

	@(posedge Q_P) begin
		if (sel == 1) begin
			r1 = ron;
			r2 = roff;
		end
    end

	@(negedge Q_P) begin
		if (sel == 1) begin
			r1 = roff;
			r2 = ron;
		end
    end

	I(RF_P,IF_P) <+ V(RF_P,IF_P)/transition(r1,td,tr,tf);
    I(RF_N,IF_N) <+ V(RF_N,IF_N)/transition(r1,td,tr,tf);

	I(RF_P,IF_N) <+ V(RF_P,IF_P)/transition(r2,td,tr,tf);
    I(RF_N,IF_P) <+ V(RF_P,IF_P)/transition(r2,td,tr,tf);
*/

  end

endmodule
