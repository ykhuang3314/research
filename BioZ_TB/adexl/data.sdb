ADE simulation setup
Run mode: Single Run, Sweeps and Corners
Tests:
  BioZ_EMG_Model:BioZ_TB:1: BioZ_EMG_Model/BioZ_TB/config, simulator ams
    Outputs: "/"; SigGen_Ioutp; SigGen_Ioutn; SigGen_IP; SigGen_IN; SigGen_QP; SigGen_QN; SigGen_Fsel; AFE_BioZ_OUT_I_DAC; AFE_BioZ_OUT_Q_DAC; AFE_I_Vout; AFE_Q_Vout; AFE_Vdiff_bioz; SigGen_Ioutdiff; AFE_TIA_I; AFE_TIA_Q; AFE_MIX_I; AFE_MIX_Q; AFE_TCA_I; AFE_TCA_Q
Global variables:
  t_meas = 4.5m
