//Verilog-AMS HDL for "EMG_202009", "ADC_V2" "verilogams"

`include "constants.vams"
`include "disciplines.vams"

module ADC_V2 (Dout, EoC, Vin, En, Clk, Start, VrefH, VrefL, Vdda, Vssa, Ibias);

//I/O ports declaration
output Dout, EoC;
input Vin, En, Clk, Start, VrefH, VrefL, Vdda, Vssa, Ibias;

//Define type of ports
electrical Vdds, Vssa, Ibias;
wreal VrefH, VrefL, Vin;
logic En, Clk, Start;
reg [11:0] Dout;
reg EoC;

//internal varialbes
integer count, end_count;
real Vhold, fvalue, NaN;

initial begin
	EoC <= 1'b1;
	count = 0;
	Vhold = VrefL;
	NaN = 0.0/0.0;
	end_count = 14;
end

always@(posedge Start) begin
	if(count == 0) begin
		count = 1;
	end
end

always@(posedge Clk) begin
	if(En == 1'b0) begin
		EoC <= 1'b0;
		Dout <= 0;
		Vhold = VrefL;
	end else begin
		if(count > 0) begin
			if (count < end_count) begin
				count = count + 1;
			end else begin
				count = 0;
			end
		end

		if(count == 2) begin
			Vhold = Vin; 						// sample the input
		end else if (count == 3) begin
			EoC <= 1'b0; 						// start conversion
		end else if (count == end_count) begin 	// end of conversion
			if(Vhold == NaN) begin
				Dout <= 11'b0;
			end else if (VrefH == NaN) begin
				Dout <= 11'bx;
			end else if (Vhold > VrefH) begin
				Dout <= 12'd4095;
			end else if (VrefL == NaN) begin
				Dout <= 11'bx;
			end else if (Vhold < VrefL) begin
				Dout <= 11'b0;
			end else begin
				fvalue = 4096 * (Vhold - VrefL) / (VrefH-VrefL);
				Dout <= $rtoi(fvalue + 0.5); 		// convet real number to int by truncation
			end
			EoC <= 1'b1;							// End of conversion
		end
	end
end

endmodule
