//Verilog-AMS HDL for "BioZ_EMG_Model", "BioZ_PLL_TOP" "verilogams"

`include "constants.vams"
`include "disciplines.vams"

module BioZ_PLL_TOP ();
    electrical gnd;
    ground gnd;
    reg ref, reset;

    initial begin
	ref = 0;
	reset = 1;
	#100
	reset = 0;
    end
    always #3333 ref = ~ref;  // 15MHz

    pfd PFD (.reset(reset), .qinc(up), .active(fb) , .ref(ref), .qdec(dwn));
    cp #(.cur(1m)) CP (.nout(gnd), .dec(dwn), .inc(up), .pout(err));
    capacitor #(.c(30n)) C (err, err2);
    resistor #(.r(200)) R (err2, gnd);
    vco #(.f0(1.5E9), .kvco(50.0E6), .rin(100k)) VCO (.ps(err), .ns(gnd), .out(out));
    fd FD (.reset(reset), .out(fb), .clk(out));
endmodule
