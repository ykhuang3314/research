ADE simulation setup
Run mode: Single Run, Sweeps and Corners
Tests:
  EMG_TestBench:TB_EMG_w_SwitchArray:1: EMG_TestBench/TB_EMG_w_SwitchArray/config, simulator ams
